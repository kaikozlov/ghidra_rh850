// Canonical RH850/P1M-E executable device description.
// Register descriptions migrated from data/p1m_sfr_labels.csv; that CSV is now a generated projection.
property evidence { type = string; component = addrmap | mem | reg; };
property source_ref { type = string; component = addrmap | mem | reg; };
property behavior { type = string; component = reg; };
property executable { type = boolean; component = mem; };
property access_widths { type = string; component = reg; };
property alias_group { type = string; component = mem; };
property reset_policy { type = string; component = mem; };
property product_ids { type = string; component = addrmap; };
property p_bus_hz { type = longint unsigned; component = addrmap; };
property trigger { type = string; component = reg; };
property status_register { type = string; component = reg; };
property secondary_status_register { type = string; component = reg; };
property access_register { type = string; component = reg; };
property history_register { type = string; component = reg; };
property reload_prefix { type = string; component = reg; };
property counter_prefix { type = string; component = reg; };
property interrupt_channel { type = longint unsigned; component = reg; };
property interrupt_register { type = string; component = reg; };
property interrupt_register_prefix { type = string; component = reg; };
property interrupt_channel_base { type = longint unsigned; component = reg; };
property mode_prefix { type = string; component = reg; };
property prescaler_register { type = string; component = reg; };
property control_register { type = string; component = reg; };
property pointer_register { type = string; component = reg; };
property window_register { type = string; component = reg; };
property channel_control_register { type = string; component = reg; };
property global_control_register { type = string; component = reg; };
property fifo_index { type = longint unsigned; component = reg; };
property fifo_channel { type = longint unsigned; component = reg; };
property payload_address { type = longint unsigned; component = reg; };
property completion_value { type = longint unsigned; component = reg; };
property channel_count { type = longint unsigned; component = reg; };
property reset_control { type = string; component = mem; };
property reset_rules { type = string; component = mem; };

addrmap p1me {
    desc = "Renesas RH850/P1M-E R7F701381/R7F701383 functional machine model";
    evidence = "manual";
    source_ref = "R01UH0585EJ0120 Rev.1.20; R01UH0615EJ0120 Rev.1.20; R01US0123EJ0140 Rev.1.40";
    product_ids = "R7F701381,R7F701383";
    p_bus_hz = 80000000;

    external mem { memwidth=8; mementries=0x100000; sw=r; evidence="manual"; source_ref="R01UH0585EJ0120 Table 4.1"; executable=true; reset_policy="retained nonvolatile"; } codeflash_user @ 0x00000000;
    external mem { memwidth=8; mementries=0x8000; sw=r; evidence="manual"; source_ref="R01UH0585EJ0120 Table 4.1"; executable=true; reset_policy="retained nonvolatile"; } codeflash_extended @ 0x01000000;
    external mem { memwidth=8; mementries=0x8000; sw=rw; evidence="manual"; source_ref="R01UH0585EJ0120 Table 4.1"; executable=false; reset_policy="retained nonvolatile; FACI writes only"; } dataflash @ 0xFF200000;
    external mem {
        memwidth=8; mementries=0x20000; sw=rw; evidence="manual"; source_ref="R01UH0585EJ0120 Table 4.1";
        executable=true; alias_group="local_ram"; reset_policy="STAC_LM0 by reset class"; reset_control="STAC_LM0";
        reset_rules="power-on:force;system-1-cvm:force;system-1-pin:controlled;system-2:controlled;application-1:controlled";
    } local_ram_pe1 @ 0xFEBE0000;
    external mem { memwidth=8; mementries=0x20000; sw=rw; evidence="manual"; source_ref="R01UH0585EJ0120 Table 4.1"; executable=true; alias_group="local_ram"; reset_policy="STAC_LM0 by reset class"; } local_ram_self @ 0xFEDE0000;
    external mem {
        memwidth=8; mementries=0x10000; sw=rw; evidence="manual"; source_ref="R01UH0585EJ0120 Table 4.1";
        executable=true; reset_policy="STAC_GRAM for Application Reset 1"; reset_control="STAC_GRAM";
        reset_rules="power-on:force;system-1-cvm:force;system-1-pin:force;system-2:force;application-1:controlled";
    } global_ram @ 0xFEEF8000;

    reg {
        regwidth=32; accesswidth=32; desc="Self-programming ID input word 0";
        evidence="manual"; source_ref="R01UH0615EJ0120 sections 3.3 and 4"; behavior="faci";
        field { sw=w; } value[31:0];
    } SELFID0 @ 0xFFA08000;

    reg {
        regwidth=32; accesswidth=32; desc="Self-programming ID input word 1";
        evidence="manual"; source_ref="R01UH0615EJ0120 sections 3.3 and 4"; behavior="faci";
        field { sw=w; } value[31:0];
    } SELFID1 @ 0xFFA08004;

    reg {
        regwidth=32; accesswidth=32; desc="Self-programming ID input word 2";
        evidence="manual"; source_ref="R01UH0615EJ0120 sections 3.3 and 4"; behavior="faci";
        field { sw=w; } value[31:0];
    } SELFID2 @ 0xFFA08008;

    reg {
        regwidth=32; accesswidth=32; desc="Self-programming ID input word 3";
        evidence="manual"; source_ref="R01UH0615EJ0120 sections 3.3 and 4"; behavior="faci";
        field { sw=w; } value[31:0];
    } SELFID3 @ 0xFFA0800C;

    reg {
        regwidth=8; accesswidth=8; desc="Self-programming ID authentication status";
        evidence="manual"; source_ref="R01UH0615EJ0120 sections 3.3 and 4"; behavior="faci";
        field { sw=r; } value[7:0];
    } SELFIDST @ 0xFFA08010;

    reg {
        regwidth=8; accesswidth=8; desc="Flash pin monitor";
        evidence="manual"; source_ref="R01UH0615EJ0120 sections 3.3 and 4"; behavior="faci";
        field { sw=r; } value[7:0];
    } FPMON @ 0xFFA10000;

    reg {
        regwidth=8; accesswidth=8; desc="Flash access status";
        evidence="manual"; source_ref="R01UH0615EJ0120 sections 3.3 and 4"; behavior="faci";
        field { sw=rw; } value[7:0];
    } FASTAT @ 0xFFA10010;

    reg {
        regwidth=8; accesswidth=8; desc="Flash access-error interrupt enable";
        evidence="manual"; source_ref="R01UH0615EJ0120 sections 3.3 and 4"; behavior="faci";
        field { sw=rw; } value[7:0];
    } FAEINT @ 0xFFA10014;

    reg {
        regwidth=16; accesswidth=16; desc="CodeFlash memory-area selector";
        evidence="manual"; source_ref="R01UH0615EJ0120 sections 3.3 and 4"; behavior="faci";
        field { sw=rw; } value[15:0];
    } FAREASELC @ 0xFFA10020;

    reg {
        regwidth=32; accesswidth=32; desc="FACI command start address";
        evidence="manual"; source_ref="R01UH0615EJ0120 sections 3.3 and 4"; behavior="faci";
        field { sw=rw; } value[31:0];
    } FSADDR @ 0xFFA10030;

    reg {
        regwidth=32; accesswidth=32; desc="FACI command end address";
        evidence="manual"; source_ref="R01UH0615EJ0120 sections 3.3 and 4"; behavior="faci";
        field { sw=rw; } value[31:0];
    } FEADDR @ 0xFFA10034;

    reg {
        regwidth=32; accesswidth=32; desc="Flash sequencer status";
        evidence="manual"; source_ref="R01UH0615EJ0120 sections 3.3 and 4"; behavior="faci";
        access_widths="1,2,4";
        field { sw=r; reset=0x8000; } value[31:0];
    } FSTATR @ 0xFFA10080;

    reg {
        regwidth=16; accesswidth=16; desc="Flash program-or-erase mode entry";
        evidence="manual"; source_ref="R01UH0615EJ0120 sections 3.3 and 4"; behavior="faci";
        field { sw=rw; } value[15:0];
    } FENTRYR @ 0xFFA10084;

    reg {
        regwidth=16; accesswidth=16; desc="CodeFlash protection control";
        evidence="manual"; source_ref="R01UH0615EJ0120 sections 3.3 and 4"; behavior="faci";
        field { sw=rw; } value[15:0];
    } FPROTR @ 0xFFA10088;

    reg {
        regwidth=16; accesswidth=16; desc="Flash sequencer setup initialization";
        evidence="manual"; source_ref="R01UH0615EJ0120 sections 3.3 and 4"; behavior="faci";
        field { sw=rw; } value[15:0];
    } FSUINITR @ 0xFFA1008C;

    reg {
        regwidth=8; accesswidth=8; desc="Flash lock-bit status";
        evidence="manual"; source_ref="R01UH0615EJ0120 sections 3.3 and 4"; behavior="faci";
        field { sw=r; } value[7:0];
    } FLKSTAT @ 0xFFA10090;

    reg {
        regwidth=8; accesswidth=8; desc="FACI reset-transfer status";
        evidence="manual"; source_ref="R01UH0615EJ0120 sections 3.3 and 4"; behavior="faci";
        field { sw=r; } value[7:0];
    } FRTSTAT @ 0xFFA10098;

    reg {
        regwidth=8; accesswidth=8; desc="FACI reset-transfer error interrupt enable";
        evidence="manual"; source_ref="R01UH0615EJ0120 sections 3.3 and 4"; behavior="faci";
        field { sw=rw; } value[7:0];
    } FRTEINT @ 0xFFA1009C;

    reg {
        regwidth=16; accesswidth=16; desc="Last FACI command";
        evidence="manual"; source_ref="R01UH0615EJ0120 sections 3.3 and 4"; behavior="faci";
        field { sw=r; reset=0xffff; } value[15:0];
    } FCMDR @ 0xFFA100A0;

    reg {
        regwidth=16; accesswidth=16; desc="Flash program-or-erase status";
        evidence="manual"; source_ref="R01UH0615EJ0120 sections 3.3 and 4"; behavior="faci";
        field { sw=r; } value[15:0];
    } FPESTAT @ 0xFFA100C0;

    reg {
        regwidth=8; accesswidth=8; desc="DataFlash blank-check control";
        evidence="manual"; source_ref="R01UH0615EJ0120 sections 3.3 and 4"; behavior="faci";
        field { sw=rw; } value[7:0];
    } FBCCNT @ 0xFFA100D0;

    reg {
        regwidth=8; accesswidth=8; desc="DataFlash blank-check status";
        evidence="manual"; source_ref="R01UH0615EJ0120 sections 3.3 and 4"; behavior="faci";
        field { sw=r; } value[7:0];
    } FBCSTAT @ 0xFFA100D4;

    reg {
        regwidth=32; accesswidth=32; desc="First programmed DataFlash address";
        evidence="manual"; source_ref="R01UH0615EJ0120 sections 3.3 and 4"; behavior="faci";
        field { sw=r; } value[31:0];
    } FPSADDR @ 0xFFA100D8;

    reg {
        regwidth=16; accesswidth=16; desc="Flash sequencer process switch";
        evidence="manual"; source_ref="R01UH0615EJ0120 sections 3.3 and 4"; behavior="faci";
        field { sw=rw; } value[15:0];
    } FCPSR @ 0xFFA100E0;

    reg {
        regwidth=16; accesswidth=16; desc="Flash sequencer processing-clock notification";
        evidence="manual"; source_ref="R01UH0615EJ0120 sections 3.3 and 4"; behavior="faci";
        field { sw=rw; } value[15:0];
    } FPCKAR @ 0xFFA100E4;

    reg {
        regwidth=16; accesswidth=16; desc="Flash ECC encoder monitor";
        evidence="manual"; source_ref="R01UH0615EJ0120 sections 3.3 and 4"; behavior="faci";
        field { sw=r; } value[15:0];
    } FECCEMON @ 0xFFA10100;

    reg {
        regwidth=16; accesswidth=16; desc="Flash ECC test-mode control";
        evidence="manual"; source_ref="R01UH0615EJ0120 sections 3.3 and 4"; behavior="faci";
        field { sw=rw; } value[15:0];
    } FECCTMD @ 0xFFA10104;

    reg {
        regwidth=16; accesswidth=16; desc="Flash dummy ECC value";
        evidence="manual"; source_ref="R01UH0615EJ0120 sections 3.3 and 4"; behavior="faci";
        field { sw=rw; } value[15:0];
    } FDMYECC @ 0xFFA10108;

    reg {
        regwidth=8; accesswidth=8; desc="FACI command-issuing area";
        evidence="manual"; source_ref="R01UH0615EJ0120 sections 3.3 and 4"; behavior="faci";
        trigger="faci-command"; status_register="FSTATR"; access_register="FASTAT"; history_register="FCMDR";
        field { sw=w; } value[7:0];
    } FACI_COMMAND_AREA @ 0xFFA20000;

    reg {
        regwidth=16; accesswidth=16; desc="Boot-flash area selector";
        evidence="manual"; source_ref="R01UH0615EJ0120 sections 3.3 and 4"; behavior="faci";
        field { sw=rw; } value[15:0];
    } BFASELR @ 0xFFC59008;

    reg {
        regwidth=32; accesswidth=32; desc="ICU-S command register; recovered MAC generate writes (selector<<16)|5 and CMAC verify writes (selector<<16)|7";
        evidence="recovered"; source_ref="Exact target CodeFlash ICU-S driver accesses; public P1M-E manual only identifies ICU-S presence"; behavior="icus_recovered";
        trigger="icus-command"; status_register="ICUSSTS"; secondary_status_register="ICUSSTS2";
        field { sw=rw; } value[31:0];
    } ICUSCMD @ 0xFFC5D000;

    reg {
        regwidth=32; accesswidth=32; desc="ICU-S data/parameter word written beside ICUSCMD (firmware role)";
        evidence="recovered"; source_ref="Exact target CodeFlash ICU-S driver accesses; public P1M-E manual only identifies ICU-S presence"; behavior="icus_recovered";
        field { sw=rw; } value[31:0];
    } ICUSDAT @ 0xFFC5D004;

    reg {
        regwidth=32; accesswidth=32; desc="ICU-S output word consumed by recovered completion callbacks";
        evidence="recovered"; source_ref="Exact target CodeFlash callbacks at 0x0008A514 and 0x0008A58A"; behavior="icus_recovered";
        field { sw=rw; } value[31:0];
    } ICUSOUT @ 0xFFC5D008;

    reg {
        regwidth=32; accesswidth=32; desc="ICU-S status; driver polls bit 0 as busy/ready";
        evidence="recovered"; source_ref="Exact target CodeFlash ICU-S driver accesses; public P1M-E manual only identifies ICU-S presence"; behavior="icus_recovered";
        field { sw=rw; } value[31:0];
    } ICUSSTS @ 0xFFC5D00C;

    reg {
        regwidth=32; accesswidth=32; desc="ICU-S companion status; driver polls low bits with ICUSSTS";
        evidence="recovered"; source_ref="Exact target CodeFlash ICU-S driver accesses; public P1M-E manual only identifies ICU-S presence"; behavior="icus_recovered";
        field { sw=rw; } value[31:0];
    } ICUSSTS2 @ 0xFFC5D014;

    reg {
        regwidth=32; accesswidth=32; desc="ICU-S interrupt/status word read by the recovered service dispatcher";
        evidence="recovered"; source_ref="Exact target CodeFlash dispatcher at 0x0008A4CE"; behavior="icus_recovered";
        field { sw=rw; } value[31:0];
    } ICUSIRQSTS @ 0xFFC5D018;

    reg {
        regwidth=32; accesswidth=32; desc="ICU-S operation parameter written by recovered command setup";
        evidence="recovered"; source_ref="Exact target CodeFlash command setup at 0x0008A63C"; behavior="icus_recovered";
        field { sw=rw; } value[31:0];
    } ICUSPARAM @ 0xFFC5D01C;

    reg {
        regwidth=32; accesswidth=32; desc="ICU-S control/acknowledgement word written by recovered callbacks and reset paths";
        evidence="recovered"; source_ref="Exact target CodeFlash callbacks at 0x0008A538 and 0x0008A5AE; driver reset path"; behavior="icus_recovered";
        field { sw=rw; } value[31:0];
    } ICUSCTL @ 0xFFC5D024;

    reg {
        regwidth=32; accesswidth=32; desc="CodeFlash error-information control";
        evidence="manual"; source_ref="R01UH0585EJ0120 section 31.2.2"; behavior="storage";
        field { sw=rw; } value[31:0];
    } UCFERRINT @ 0xFFC62000;

    reg {
        regwidth=32; accesswidth=32; desc="CodeFlash ECC single-error status clear";
        evidence="manual"; source_ref="R01UH0585EJ0120 section 31.2.2"; behavior="storage";
        field { sw=w; } value[31:0];
    } UCFSERSTCLR @ 0xFFC62004;

    reg {
        regwidth=32; accesswidth=32; desc="CodeFlash ECC double-error and address-parity status clear";
        evidence="manual"; source_ref="R01UH0585EJ0120 section 31.2.2"; behavior="storage";
        field { sw=w; } value[31:0];
    } UCFDERSTCLR @ 0xFFC62008;

    reg {
        regwidth=32; accesswidth=32; desc="CodeFlash single-error count overflow status";
        evidence="manual"; source_ref="R01UH0585EJ0120 section 31.2.2"; behavior="storage";
        field { sw=r; } value[31:0];
    } UCFOVFSTR @ 0xFFC6200C;

    reg {
        regwidth=32; accesswidth=32; desc="CodeFlash ECC single-error status";
        evidence="manual"; source_ref="R01UH0585EJ0120 section 31.2.2"; behavior="storage";
        field { sw=r; } value[31:0];
    } UCFSERSTR @ 0xFFC62020;

    reg {
        regwidth=32; accesswidth=32; desc="CodeFlash ECC double-error and address-parity status";
        evidence="manual"; source_ref="R01UH0585EJ0120 section 31.2.2"; behavior="storage";
        field { sw=r; } value[31:0];
    } UCFDERSTR @ 0xFFC62030;

    reg {
        regwidth=32; accesswidth=32; desc="CodeFlash first single-error address";
        evidence="manual"; source_ref="R01UH0585EJ0120 section 31.2.2"; behavior="storage";
        field { sw=r; } value[31:0];
    } UCF1SEDADR @ 0xFFC62040;

    reg {
        regwidth=32; accesswidth=32; desc="CodeFlash second single-error address";
        evidence="manual"; source_ref="R01UH0585EJ0120 section 31.2.2"; behavior="storage";
        field { sw=r; } value[31:0];
    } UCF2SEDADR @ 0xFFC62044;

    reg {
        regwidth=32; accesswidth=32; desc="CodeFlash third single-error address";
        evidence="manual"; source_ref="R01UH0585EJ0120 section 31.2.2"; behavior="storage";
        field { sw=r; } value[31:0];
    } UCF3SEDADR @ 0xFFC62048;

    reg {
        regwidth=32; accesswidth=32; desc="CodeFlash fourth single-error address";
        evidence="manual"; source_ref="R01UH0585EJ0120 section 31.2.2"; behavior="storage";
        field { sw=r; } value[31:0];
    } UCF4SEDADR @ 0xFFC6204C;

    reg {
        regwidth=32; accesswidth=32; desc="CodeFlash double-error or address-parity error address";
        evidence="manual"; source_ref="R01UH0585EJ0120 section 31.2.2"; behavior="storage";
        field { sw=r; } value[31:0];
    } UCFDEDADR @ 0xFFC620C0;

    reg {
        regwidth=32; accesswidth=32; desc="CodeFlash address-parity control";
        evidence="manual"; source_ref="R01UH0585EJ0120 section 31.2.2"; behavior="storage";
        field { sw=rw; } value[31:0];
    } CFAPCTL @ 0xFFC62100;

    reg {
        regwidth=32; accesswidth=32; desc="CodeFlash ECC control for system-interconnect access";
        evidence="manual"; source_ref="R01UH0585EJ0120 section 31.2.2"; behavior="storage";
        field { sw=rw; } value[31:0];
    } CFECCCTL_VCI2CFBA @ 0xFFC62200;

    reg {
        regwidth=32; accesswidth=32; desc="CodeFlash ECC sub-test control for system-interconnect access";
        evidence="manual"; source_ref="R01UH0585EJ0120 section 31.2.2"; behavior="storage";
        field { sw=rw; } value[31:0];
    } CFSTSTCTL_VCI2CFBA @ 0xFFC622F0;

    reg {
        regwidth=32; accesswidth=32; desc="CodeFlash ECC control for PE1 access";
        evidence="manual"; source_ref="R01UH0585EJ0120 section 31.2.2"; behavior="storage";
        field { sw=rw; } value[31:0];
    } CFECCCTL_PE1 @ 0xFFC62400;

    reg {
        regwidth=32; accesswidth=32; desc="CodeFlash ECC sub-test control for PE1 access";
        evidence="manual"; source_ref="R01UH0585EJ0120 section 31.2.2"; behavior="storage";
        field { sw=rw; } value[31:0];
    } CFSTSTCTL_PE1 @ 0xFFC624F0;

    reg {
        regwidth=32; accesswidth=32; desc="RSCFD0CFDCFCC3 (CFCCk = base+0x118+4k, k=3): CFIFO 3 configuration and control; CFE bit 0 enable, CFRXIE bit 1 receive-interrupt enable, CFTXIE bit 2 transmit-interrupt enable, CFPLS[6:4] payload size, CFDC[10:8] depth (0,4,8,16,32,48,64,128 messages), CFIM bit 12 interrupt source (1=every message), CFIGCV[15:13] fill threshold eighths, CFM[17:16] mode 00=receive; FIFO 3 serves CAN channel m=k/3=1";
        evidence="manual"; source_ref="R01UH0585EJ0120 Tables 17.12 and 17.132, section 17.4.8.1 (pages 797, 989-992)"; behavior="rscfd";
        status_register="CFSTS_CH1"; pointer_register="CFPCTR_CH1"; window_register="CFID_CH1"; channel_control_register="C1CTR"; global_control_register="GCTR"; interrupt_register="EIC187"; fifo_index=3; fifo_channel=1;
        field { sw=rw; reset=0; } value[31:0];
    } CFCC3 @ 0xFFD20124;

    reg {
        regwidth=32; accesswidth=32; desc="RSCFD common-FIFO status base (CFSTSk = base+0x178+4k, k=0..8)";
        evidence="manual"; source_ref="R01UH0585EJ0120 Tables 17.12 and 17.133; firmware-observed role"; behavior="rscfd";
        field { sw=rw; } value[31:0];
    } CFSTS @ 0xFFD20178;

    reg {
        regwidth=32; accesswidth=32; desc="RSCFD0CFDCFSTS3 (CFSTSk = base+0x178+4k, k=3): transmit/receive FIFO 3 status; CAN channel m=k/3=1; CFMC[15:8] message count, CFTXIF bit 4, CFRXIF bit 3, CFMLT bit 2, CFFLL bit 1, CFEMP bit 0; flags clear on write 0 to the flag with 1 elsewhere; reset CFEMP=1";
        evidence="manual"; source_ref="R01UH0585EJ0120 Tables 17.12 and 17.133, section 17.4.8.2 (pages 797, 992-995); SFR list FFD20184; firmware table 0x22FA0 stores this FIFO-3 base while native reader 0x83D40 computes the operative CFSTS5 at +8"; behavior="rscfd";
        control_register="CFCC3"; pointer_register="CFPCTR_CH1"; interrupt_register="EIC187"; fifo_index=3; fifo_channel=1;
        field { sw=rw; reset=1; } value[31:0];
    } CFSTS_CH1 @ 0xFFD20184;

    reg {
        regwidth=32; accesswidth=32; desc="RSCFD common-FIFO pointer control base (CFPCTRk = base+0x1D8+4k, k=0..8; write 0xFF to CFPC[7:0] advances)";
        evidence="manual"; source_ref="R01UH0585EJ0120 section 17, RSCFD register tables; firmware-observed role"; behavior="rscfd";
        field { sw=rw; } value[31:0];
    } CFPCTR @ 0xFFD201D8;

    reg {
        regwidth=32; accesswidth=32; desc="RSCFD0CFDCFPCTR3 (CFPCTRk = base+0x1D8+4k, k=3): CFIFO 3 pointer control; CFPC[7:0] write-only; receive mode: write 0xFF moves the read pointer to the next unread message and decrements CFMC (requires CFE=1 and CFEMP=0)";
        evidence="manual"; source_ref="R01UH0585EJ0120 Tables 17.12 and 17.134, section 17.4.8.3 (pages 797, 996-997); SFR list FFD201E4; firmware table 0x22FAC stores this FIFO-3 base while native reader 0x83D40 computes the operative CFPCTR5 at +8"; behavior="rscfd";
        status_register="CFSTS_CH1"; control_register="CFCC3"; fifo_index=3; fifo_channel=1;
        field { sw=w; } value[31:0];
    } CFPCTR_CH1 @ 0xFFD201E4;

    reg {
        regwidth=32; accesswidth=32; desc="RSCFD Tx message-buffer control base (CFDTMCn.TMTR at +n)";
        evidence="manual"; source_ref="R01UH0585EJ0120 section 17, RSCFD register tables; firmware-observed role"; behavior="rscfd";
        field { sw=rw; } value[31:0];
    } CFDTMC @ 0xFFD20250;

    reg {
        regwidth=8; accesswidth=8; desc="Diagnostic Tx buffer control (HTH 0x13 -> n=16; TMTR bit 0)";
        evidence="manual"; source_ref="R01UH0585EJ0120 section 17, RSCFD register tables; firmware-observed role"; behavior="rscfd";
        trigger="rscfd-transmit"; payload_address=0xFFD24200; status_register="CFDTMSTS_CH1"; completion_value=4;
        field { sw=rw; } value[7:0];
    } CFDTMC16 @ 0xFFD20260;

    reg {
        regwidth=8; accesswidth=8; desc="Application CAN1 Tx buffer n=16 control (TMTR bit 0)";
        evidence="manual"; source_ref="R01UH0585EJ0120 section 17, RSCFD register tables; exact firmware table binding"; behavior="rscfd";
        trigger="rscfd-transmit"; payload_address=0xFFD24400; status_register="CFDTMSTS_CH1_16"; completion_value=4;
        field { sw=rw; } value[7:0];
    } CFDTMC_CH1_16 @ 0xFFD20270;

    reg {
        regwidth=32; accesswidth=32; desc="RSCFD Tx message-buffer status base (CFDTMSTSn at +n)";
        evidence="manual"; source_ref="R01UH0585EJ0120 section 17, RSCFD register tables; firmware-observed role"; behavior="rscfd";
        field { sw=rw; } value[31:0];
    } CFDTMSTS @ 0xFFD202D0;

    reg {
        regwidth=32; accesswidth=32; desc="RSCFD Tx status base for application CAN1 record";
        evidence="manual"; source_ref="R01UH0585EJ0120 section 17, RSCFD register tables; firmware-observed role"; behavior="rscfd";
        field { sw=rw; } value[31:0];
    } CFDTMSTS_CH1 @ 0xFFD202E0;

    reg {
        regwidth=8; accesswidth=8; desc="Application CAN1 Tx buffer n=16 status";
        evidence="manual"; source_ref="R01UH0585EJ0120 section 17, RSCFD register tables; exact firmware table binding"; behavior="rscfd";
        field { sw=rw; } value[7:0];
    } CFDTMSTS_CH1_16 @ 0xFFD202F0;

    reg {
        regwidth=32; accesswidth=32; desc="RSCFD common-FIFO access-window base (CFIDk = base+0x3400+0x80k, k=0..8; window: ID, +4 PTR, +8 FDCSTS, +0x0C..+0x48 DF0..DF15)";
        evidence="manual"; source_ref="R01UH0585EJ0120 section 17, RSCFD register tables; firmware-observed role"; behavior="rscfd";
        field { sw=rw; } value[31:0];
    } CFID @ 0xFFD23400;

    reg {
        regwidth=32; accesswidth=32; desc="RSCFD0CFDCFID3 (CFIDk = base+0x3400+0x80k, k=3): CFIFO 3 access window; CFIDE bit 31, CFRTR bit 30, CFID[28:0]; +0x04 CFDCFPTR3 (CFDLC[31:28], CFPTR[27:16], CFTS[15:0]), +0x08 CFDCFFDCSTS3 (CFFDF bit 2, CFBRS bit 1, CFESI bit 0), +0x0C CFDCFDF0_3 .. +0x48 CFDCFDF15_3 (16 data words); receive mode reads alias the oldest unread message";
        evidence="manual"; source_ref="R01UH0585EJ0120 Tables 17.12, 17.135-17.138, section 17.4.8.4-17.4.8.7 (pages 797-798, 997-1004); SFR list FFD23580-FFD235C8; firmware table 0x22FB4 stores this FIFO-3 window base while native reader 0x83D40 computes the operative CFID5 at +0x100"; behavior="rscfd";
        status_register="CFSTS_CH1"; fifo_index=3; fifo_channel=1;
        access_widths="1,2,4";
        field { sw=r; reset=0; } value[31:0];
    } CFID_CH1 @ 0xFFD23580;

    reg {
        regwidth=32; accesswidth=32; desc="RSCFD0CFDCFPTR3 (CFID3 window +0x04): CFIFO 3 access pointer; CFDLC[31:28] DLC of the unread message (CAN FD: 9-15 = 12/16/20/24/32/48/64 bytes), CFPTR[27:16] label, CFTS[15:0] timestamp; read-only in receive mode";
        evidence="manual"; source_ref="R01UH0585EJ0120 Table 17.136, section 17.4.8.5 (pages 999-1001); SFR list FFD23584"; behavior="rscfd";
        status_register="CFSTS_CH1"; fifo_index=3; fifo_channel=1;
        access_widths="1,2,4";
        field { sw=r; reset=0; } value[31:0];
    } CFPTR_CH1 @ 0xFFD23584;

    reg {
        regwidth=32; accesswidth=32; desc="RSCFD0CFDCFFDCSTS3 (CFID3 window +0x08): CFIFO 3 CAN FD configuration/status; CFFDF bit 2 (1=CAN FD frame), CFBRS bit 1, CFESI bit 0";
        evidence="manual"; source_ref="R01UH0585EJ0120 Table 17.137, section 17.4.8.6 (pages 1001-1002); SFR list FFD23588"; behavior="rscfd";
        status_register="CFSTS_CH1"; fifo_index=3; fifo_channel=1;
        access_widths="1,2,4";
        field { sw=r; reset=0; } value[31:0];
    } CFFDCSTS_CH1 @ 0xFFD23588;

    reg {
        regwidth=32; accesswidth=32; desc="RSCFD0CFDCFDF0_3 (CFID3 window +0x0C): CFIFO 3 unread-message data bytes 0..3; read-only in receive mode";
        evidence="manual"; source_ref="R01UH0585EJ0120 section 17.4.8.7, Tables 17.12 and 17.138 (page 1003); SFR list FFD2358C"; behavior="rscfd";
        status_register="CFSTS_CH1"; fifo_index=3; fifo_channel=1;
        access_widths="1,2,4";
        field { sw=r; reset=0; } value[31:0];
    } CFDF0_CH1 @ 0xFFD2358C;

    reg {
        regwidth=32; accesswidth=32; desc="RSCFD0CFDCFDF1_3 (CFID3 window +0x10): CFIFO 3 unread-message data bytes 4..7; read-only in receive mode";
        evidence="manual"; source_ref="R01UH0585EJ0120 section 17.4.8.7, Tables 17.12 and 17.138 (page 1003); SFR list FFD23590"; behavior="rscfd";
        status_register="CFSTS_CH1"; fifo_index=3; fifo_channel=1;
        access_widths="1,2,4";
        field { sw=r; reset=0; } value[31:0];
    } CFDF1_CH1 @ 0xFFD23590;

    reg {
        regwidth=32; accesswidth=32; desc="RSCFD0CFDCFDF2_3 (CFID3 window +0x14): CFIFO 3 unread-message data bytes 8..11; read-only in receive mode";
        evidence="manual"; source_ref="R01UH0585EJ0120 section 17.4.8.7, Tables 17.12 and 17.138 (page 1003); SFR list FFD23594"; behavior="rscfd";
        status_register="CFSTS_CH1"; fifo_index=3; fifo_channel=1;
        access_widths="1,2,4";
        field { sw=r; reset=0; } value[31:0];
    } CFDF2_CH1 @ 0xFFD23594;

    reg {
        regwidth=32; accesswidth=32; desc="RSCFD0CFDCFDF3_3 (CFID3 window +0x18): CFIFO 3 unread-message data bytes 12..15; read-only in receive mode";
        evidence="manual"; source_ref="R01UH0585EJ0120 section 17.4.8.7, Tables 17.12 and 17.138 (page 1003); SFR list FFD23598"; behavior="rscfd";
        status_register="CFSTS_CH1"; fifo_index=3; fifo_channel=1;
        access_widths="1,2,4";
        field { sw=r; reset=0; } value[31:0];
    } CFDF3_CH1 @ 0xFFD23598;

    reg {
        regwidth=32; accesswidth=32; desc="RSCFD0CFDCFDF4_3 (CFID3 window +0x1C): CFIFO 3 unread-message data bytes 16..19; read-only in receive mode";
        evidence="manual"; source_ref="R01UH0585EJ0120 section 17.4.8.7, Tables 17.12 and 17.138 (page 1003); SFR list FFD2359C"; behavior="rscfd";
        status_register="CFSTS_CH1"; fifo_index=3; fifo_channel=1;
        access_widths="1,2,4";
        field { sw=r; reset=0; } value[31:0];
    } CFDF4_CH1 @ 0xFFD2359C;

    reg {
        regwidth=32; accesswidth=32; desc="RSCFD0CFDCFDF5_3 (CFID3 window +0x20): CFIFO 3 unread-message data bytes 20..23; read-only in receive mode";
        evidence="manual"; source_ref="R01UH0585EJ0120 section 17.4.8.7, Tables 17.12 and 17.138 (page 1003); SFR list FFD235A0"; behavior="rscfd";
        status_register="CFSTS_CH1"; fifo_index=3; fifo_channel=1;
        access_widths="1,2,4";
        field { sw=r; reset=0; } value[31:0];
    } CFDF5_CH1 @ 0xFFD235A0;

    reg {
        regwidth=32; accesswidth=32; desc="RSCFD0CFDCFDF6_3 (CFID3 window +0x24): CFIFO 3 unread-message data bytes 24..27; read-only in receive mode";
        evidence="manual"; source_ref="R01UH0585EJ0120 section 17.4.8.7, Tables 17.12 and 17.138 (page 1003); SFR list FFD235A4"; behavior="rscfd";
        status_register="CFSTS_CH1"; fifo_index=3; fifo_channel=1;
        access_widths="1,2,4";
        field { sw=r; reset=0; } value[31:0];
    } CFDF6_CH1 @ 0xFFD235A4;

    reg {
        regwidth=32; accesswidth=32; desc="RSCFD0CFDCFDF7_3 (CFID3 window +0x28): CFIFO 3 unread-message data bytes 28..31; read-only in receive mode";
        evidence="manual"; source_ref="R01UH0585EJ0120 section 17.4.8.7, Tables 17.12 and 17.138 (page 1003); SFR list FFD235A8"; behavior="rscfd";
        status_register="CFSTS_CH1"; fifo_index=3; fifo_channel=1;
        access_widths="1,2,4";
        field { sw=r; reset=0; } value[31:0];
    } CFDF7_CH1 @ 0xFFD235A8;

    reg {
        regwidth=32; accesswidth=32; desc="RSCFD0CFDCFDF8_3 (CFID3 window +0x2C): CFIFO 3 unread-message data bytes 32..35; read-only in receive mode";
        evidence="manual"; source_ref="R01UH0585EJ0120 section 17.4.8.7, Tables 17.12 and 17.138 (page 1003); SFR list FFD235AC"; behavior="rscfd";
        status_register="CFSTS_CH1"; fifo_index=3; fifo_channel=1;
        access_widths="1,2,4";
        field { sw=r; reset=0; } value[31:0];
    } CFDF8_CH1 @ 0xFFD235AC;

    reg {
        regwidth=32; accesswidth=32; desc="RSCFD0CFDCFDF9_3 (CFID3 window +0x30): CFIFO 3 unread-message data bytes 36..39; read-only in receive mode";
        evidence="manual"; source_ref="R01UH0585EJ0120 section 17.4.8.7, Tables 17.12 and 17.138 (page 1003); SFR list FFD235B0"; behavior="rscfd";
        status_register="CFSTS_CH1"; fifo_index=3; fifo_channel=1;
        access_widths="1,2,4";
        field { sw=r; reset=0; } value[31:0];
    } CFDF9_CH1 @ 0xFFD235B0;

    reg {
        regwidth=32; accesswidth=32; desc="RSCFD0CFDCFDF10_3 (CFID3 window +0x34): CFIFO 3 unread-message data bytes 40..43; read-only in receive mode";
        evidence="manual"; source_ref="R01UH0585EJ0120 section 17.4.8.7, Tables 17.12 and 17.138 (page 1003); SFR list FFD235B4"; behavior="rscfd";
        status_register="CFSTS_CH1"; fifo_index=3; fifo_channel=1;
        access_widths="1,2,4";
        field { sw=r; reset=0; } value[31:0];
    } CFDF10_CH1 @ 0xFFD235B4;

    reg {
        regwidth=32; accesswidth=32; desc="RSCFD0CFDCFDF11_3 (CFID3 window +0x38): CFIFO 3 unread-message data bytes 44..47; read-only in receive mode";
        evidence="manual"; source_ref="R01UH0585EJ0120 section 17.4.8.7, Tables 17.12 and 17.138 (page 1003); SFR list FFD235B8"; behavior="rscfd";
        status_register="CFSTS_CH1"; fifo_index=3; fifo_channel=1;
        access_widths="1,2,4";
        field { sw=r; reset=0; } value[31:0];
    } CFDF11_CH1 @ 0xFFD235B8;

    reg {
        regwidth=32; accesswidth=32; desc="RSCFD0CFDCFDF12_3 (CFID3 window +0x3C): CFIFO 3 unread-message data bytes 48..51; read-only in receive mode";
        evidence="manual"; source_ref="R01UH0585EJ0120 section 17.4.8.7, Tables 17.12 and 17.138 (page 1003); SFR list FFD235BC"; behavior="rscfd";
        status_register="CFSTS_CH1"; fifo_index=3; fifo_channel=1;
        access_widths="1,2,4";
        field { sw=r; reset=0; } value[31:0];
    } CFDF12_CH1 @ 0xFFD235BC;

    reg {
        regwidth=32; accesswidth=32; desc="RSCFD0CFDCFDF13_3 (CFID3 window +0x40): CFIFO 3 unread-message data bytes 52..55; read-only in receive mode";
        evidence="manual"; source_ref="R01UH0585EJ0120 section 17.4.8.7, Tables 17.12 and 17.138 (page 1003); SFR list FFD235C0"; behavior="rscfd";
        status_register="CFSTS_CH1"; fifo_index=3; fifo_channel=1;
        access_widths="1,2,4";
        field { sw=r; reset=0; } value[31:0];
    } CFDF13_CH1 @ 0xFFD235C0;

    reg {
        regwidth=32; accesswidth=32; desc="RSCFD0CFDCFDF14_3 (CFID3 window +0x44): CFIFO 3 unread-message data bytes 56..59; read-only in receive mode";
        evidence="manual"; source_ref="R01UH0585EJ0120 section 17.4.8.7, Tables 17.12 and 17.138 (page 1003); SFR list FFD235C4"; behavior="rscfd";
        status_register="CFSTS_CH1"; fifo_index=3; fifo_channel=1;
        access_widths="1,2,4";
        field { sw=r; reset=0; } value[31:0];
    } CFDF14_CH1 @ 0xFFD235C4;

    reg {
        regwidth=32; accesswidth=32; desc="RSCFD0CFDCFDF15_3 (CFID3 window +0x48): CFIFO 3 unread-message data bytes 60..63; read-only in receive mode";
        evidence="manual"; source_ref="R01UH0585EJ0120 section 17.4.8.7, Tables 17.12 and 17.138 (page 1003); SFR list FFD235C8"; behavior="rscfd";
        status_register="CFSTS_CH1"; fifo_index=3; fifo_channel=1;
        access_widths="1,2,4";
        field { sw=r; reset=0; } value[31:0];
    } CFDF15_CH1 @ 0xFFD235C8;

    reg {
        regwidth=32; accesswidth=32; desc="RSCFD0CFDCFCC5 (CFCCk = base+0x118+4k, k=5): CFIFO 5 configuration and control; CFE bit 0 enable, CFRXIE bit 1 receive-interrupt enable, CFTXIE bit 2 transmit-interrupt enable, CFPLS[6:4] payload size, CFDC[10:8] depth (0,4,8,16,32,48,64,128 messages), CFIM bit 12 interrupt source (1=every message), CFIGCV[15:13] fill threshold eighths, CFM[17:16] mode 00=receive; FIFO 5 serves CAN channel m=k/3=1; native diagnostic receive path: firmware config tables 0x22F68/0x22F6C store C1CTR/C1STS and 0x22FA0-0x22FB4 store FIFO-3 bases, and reader 0x83D40 computes the operative FIFO-5 registers by adding +8 to status/pointer/control and +0x100 to the window; GAFL rule 43 (GAFLID 0x7A1, label 0x34, GAFLFDP 0x2000 = bit 13-8 = k 5) targets this FIFO";
        evidence="manual"; source_ref="R01UH0585EJ0120 Tables 17.12 and 17.132, section 17.4.8.1 (pages 797, 989-992); SFR list FFD2012C; exact-firmware FIFO-5 selection at FFD2012C = stored base FFD20124 + 8"; behavior="rscfd";
        status_register="CFSTS5"; pointer_register="CFPCTR5"; window_register="CFID5"; channel_control_register="C1CTR"; global_control_register="GCTR"; interrupt_register="EIC187"; fifo_index=5; fifo_channel=1;
        field { sw=rw; reset=0; } value[31:0];
    } CFCC5 @ 0xFFD2012C;

    reg {
        regwidth=32; accesswidth=32; desc="RSCFD0CFDCFSTS5 (CFSTSk = base+0x178+4k, k=5): transmit/receive FIFO 5 status; CAN channel m=k/3=1; CFMC[15:8] message count, CFTXIF bit 4, CFRXIF bit 3, CFMLT bit 2, CFFLL bit 1, CFEMP bit 0; flags clear on write 0 to the flag with 1 elsewhere; reset CFEMP=1";
        evidence="manual"; source_ref="R01UH0585EJ0120 Tables 17.12 and 17.133, section 17.4.8.2 (pages 797, 992-995); SFR list FFD2018C; exact-firmware FIFO-5 selection at FFD2018C = stored base FFD20184 + 8"; behavior="rscfd";
        control_register="CFCC5"; pointer_register="CFPCTR5"; interrupt_register="EIC187"; fifo_index=5; fifo_channel=1;
        field { sw=rw; reset=1; } value[31:0];
    } CFSTS5 @ 0xFFD2018C;

    reg {
        regwidth=32; accesswidth=32; desc="RSCFD0CFDCFPCTR5 (CFPCTRk = base+0x1D8+4k, k=5): CFIFO 5 pointer control; CFPC[7:0] write-only; receive mode: write 0xFF moves the read pointer to the next unread message and decrements CFMC (requires CFE=1 and CFEMP=0)";
        evidence="manual"; source_ref="R01UH0585EJ0120 Tables 17.12 and 17.134, section 17.4.8.3 (pages 797, 996-997); SFR list FFD201EC; exact-firmware FIFO-5 selection at FFD201EC = stored base FFD201E4 + 8"; behavior="rscfd";
        status_register="CFSTS5"; control_register="CFCC5"; fifo_index=5; fifo_channel=1;
        field { sw=w; } value[31:0];
    } CFPCTR5 @ 0xFFD201EC;

    reg {
        regwidth=32; accesswidth=32; desc="RSCFD0CFDCFID5 (CFIDk = base+0x3400+0x80k, k=5): CFIFO 5 access window; CFIDE bit 31, CFRTR bit 30, CFID[28:0]; +0x04 CFDCFPTR5 (CFDLC[31:28], CFPTR[27:16], CFTS[15:0]), +0x08 CFDCFFDCSTS5 (CFFDF bit 2, CFBRS bit 1, CFESI bit 0), +0x0C CFDCFDF0_5 .. +0x48 CFDCFDF15_5 (16 data words); receive mode reads alias the oldest unread message";
        evidence="manual"; source_ref="R01UH0585EJ0120 Tables 17.12, 17.135-17.138, section 17.4.8.4-17.4.8.7 (pages 797-798, 997-1004); SFR list FFD23680-FFD236C8; exact-firmware FIFO-5 selection at FFD23680 = stored base FFD23580 + 0x100"; behavior="rscfd";
        status_register="CFSTS5"; fifo_index=5; fifo_channel=1;
        access_widths="1,2,4";
        field { sw=r; reset=0; } value[31:0];
    } CFID5 @ 0xFFD23680;

    reg {
        regwidth=32; accesswidth=32; desc="RSCFD0CFDCFPTR5 (CFID5 window +0x04): CFIFO 5 access pointer; CFDLC[31:28] DLC of the unread message (CAN FD: 9-15 = 12/16/20/24/32/48/64 bytes), CFPTR[27:16] label, CFTS[15:0] timestamp; read-only in receive mode";
        evidence="manual"; source_ref="R01UH0585EJ0120 Table 17.136, section 17.4.8.5 (pages 999-1001); SFR list FFD23684"; behavior="rscfd";
        status_register="CFSTS5"; fifo_index=5; fifo_channel=1;
        access_widths="1,2,4";
        field { sw=r; reset=0; } value[31:0];
    } CFPTR5 @ 0xFFD23684;

    reg {
        regwidth=32; accesswidth=32; desc="RSCFD0CFDCFFDCSTS5 (CFID5 window +0x08): CFIFO 5 CAN FD configuration/status; CFFDF bit 2 (1=CAN FD frame), CFBRS bit 1, CFESI bit 0";
        evidence="manual"; source_ref="R01UH0585EJ0120 Table 17.137, section 17.4.8.6 (pages 1001-1002); SFR list FFD23688"; behavior="rscfd";
        status_register="CFSTS5"; fifo_index=5; fifo_channel=1;
        access_widths="1,2,4";
        field { sw=r; reset=0; } value[31:0];
    } CFFDCSTS5 @ 0xFFD23688;

    reg {
        regwidth=32; accesswidth=32; desc="RSCFD0CFDCFDF0_5 (CFID5 window +0x0C): CFIFO 5 unread-message data bytes 0..3; read-only in receive mode";
        evidence="manual"; source_ref="R01UH0585EJ0120 section 17.4.8.7, Tables 17.12 and 17.138 (page 1003); SFR list FFD2368C"; behavior="rscfd";
        status_register="CFSTS5"; fifo_index=5; fifo_channel=1;
        access_widths="1,2,4";
        field { sw=r; reset=0; } value[31:0];
    } CFDF0_5 @ 0xFFD2368C;

    reg {
        regwidth=32; accesswidth=32; desc="RSCFD0CFDCFDF1_5 (CFID5 window +0x10): CFIFO 5 unread-message data bytes 4..7; read-only in receive mode";
        evidence="manual"; source_ref="R01UH0585EJ0120 section 17.4.8.7, Tables 17.12 and 17.138 (page 1003); SFR list FFD23690"; behavior="rscfd";
        status_register="CFSTS5"; fifo_index=5; fifo_channel=1;
        access_widths="1,2,4";
        field { sw=r; reset=0; } value[31:0];
    } CFDF1_5 @ 0xFFD23690;

    reg {
        regwidth=32; accesswidth=32; desc="RSCFD0CFDCFDF2_5 (CFID5 window +0x14): CFIFO 5 unread-message data bytes 8..11; read-only in receive mode";
        evidence="manual"; source_ref="R01UH0585EJ0120 section 17.4.8.7, Tables 17.12 and 17.138 (page 1003); SFR list FFD23694"; behavior="rscfd";
        status_register="CFSTS5"; fifo_index=5; fifo_channel=1;
        access_widths="1,2,4";
        field { sw=r; reset=0; } value[31:0];
    } CFDF2_5 @ 0xFFD23694;

    reg {
        regwidth=32; accesswidth=32; desc="RSCFD0CFDCFDF3_5 (CFID5 window +0x18): CFIFO 5 unread-message data bytes 12..15; read-only in receive mode";
        evidence="manual"; source_ref="R01UH0585EJ0120 section 17.4.8.7, Tables 17.12 and 17.138 (page 1003); SFR list FFD23698"; behavior="rscfd";
        status_register="CFSTS5"; fifo_index=5; fifo_channel=1;
        access_widths="1,2,4";
        field { sw=r; reset=0; } value[31:0];
    } CFDF3_5 @ 0xFFD23698;

    reg {
        regwidth=32; accesswidth=32; desc="RSCFD0CFDCFDF4_5 (CFID5 window +0x1C): CFIFO 5 unread-message data bytes 16..19; read-only in receive mode";
        evidence="manual"; source_ref="R01UH0585EJ0120 section 17.4.8.7, Tables 17.12 and 17.138 (page 1003); SFR list FFD2369C"; behavior="rscfd";
        status_register="CFSTS5"; fifo_index=5; fifo_channel=1;
        access_widths="1,2,4";
        field { sw=r; reset=0; } value[31:0];
    } CFDF4_5 @ 0xFFD2369C;

    reg {
        regwidth=32; accesswidth=32; desc="RSCFD0CFDCFDF5_5 (CFID5 window +0x20): CFIFO 5 unread-message data bytes 20..23; read-only in receive mode";
        evidence="manual"; source_ref="R01UH0585EJ0120 section 17.4.8.7, Tables 17.12 and 17.138 (page 1003); SFR list FFD236A0"; behavior="rscfd";
        status_register="CFSTS5"; fifo_index=5; fifo_channel=1;
        access_widths="1,2,4";
        field { sw=r; reset=0; } value[31:0];
    } CFDF5_5 @ 0xFFD236A0;

    reg {
        regwidth=32; accesswidth=32; desc="RSCFD0CFDCFDF6_5 (CFID5 window +0x24): CFIFO 5 unread-message data bytes 24..27; read-only in receive mode";
        evidence="manual"; source_ref="R01UH0585EJ0120 section 17.4.8.7, Tables 17.12 and 17.138 (page 1003); SFR list FFD236A4"; behavior="rscfd";
        status_register="CFSTS5"; fifo_index=5; fifo_channel=1;
        access_widths="1,2,4";
        field { sw=r; reset=0; } value[31:0];
    } CFDF6_5 @ 0xFFD236A4;

    reg {
        regwidth=32; accesswidth=32; desc="RSCFD0CFDCFDF7_5 (CFID5 window +0x28): CFIFO 5 unread-message data bytes 28..31; read-only in receive mode";
        evidence="manual"; source_ref="R01UH0585EJ0120 section 17.4.8.7, Tables 17.12 and 17.138 (page 1003); SFR list FFD236A8"; behavior="rscfd";
        status_register="CFSTS5"; fifo_index=5; fifo_channel=1;
        access_widths="1,2,4";
        field { sw=r; reset=0; } value[31:0];
    } CFDF7_5 @ 0xFFD236A8;

    reg {
        regwidth=32; accesswidth=32; desc="RSCFD0CFDCFDF8_5 (CFID5 window +0x2C): CFIFO 5 unread-message data bytes 32..35; read-only in receive mode";
        evidence="manual"; source_ref="R01UH0585EJ0120 section 17.4.8.7, Tables 17.12 and 17.138 (page 1003); SFR list FFD236AC"; behavior="rscfd";
        status_register="CFSTS5"; fifo_index=5; fifo_channel=1;
        access_widths="1,2,4";
        field { sw=r; reset=0; } value[31:0];
    } CFDF8_5 @ 0xFFD236AC;

    reg {
        regwidth=32; accesswidth=32; desc="RSCFD0CFDCFDF9_5 (CFID5 window +0x30): CFIFO 5 unread-message data bytes 36..39; read-only in receive mode";
        evidence="manual"; source_ref="R01UH0585EJ0120 section 17.4.8.7, Tables 17.12 and 17.138 (page 1003); SFR list FFD236B0"; behavior="rscfd";
        status_register="CFSTS5"; fifo_index=5; fifo_channel=1;
        access_widths="1,2,4";
        field { sw=r; reset=0; } value[31:0];
    } CFDF9_5 @ 0xFFD236B0;

    reg {
        regwidth=32; accesswidth=32; desc="RSCFD0CFDCFDF10_5 (CFID5 window +0x34): CFIFO 5 unread-message data bytes 40..43; read-only in receive mode";
        evidence="manual"; source_ref="R01UH0585EJ0120 section 17.4.8.7, Tables 17.12 and 17.138 (page 1003); SFR list FFD236B4"; behavior="rscfd";
        status_register="CFSTS5"; fifo_index=5; fifo_channel=1;
        access_widths="1,2,4";
        field { sw=r; reset=0; } value[31:0];
    } CFDF10_5 @ 0xFFD236B4;

    reg {
        regwidth=32; accesswidth=32; desc="RSCFD0CFDCFDF11_5 (CFID5 window +0x38): CFIFO 5 unread-message data bytes 44..47; read-only in receive mode";
        evidence="manual"; source_ref="R01UH0585EJ0120 section 17.4.8.7, Tables 17.12 and 17.138 (page 1003); SFR list FFD236B8"; behavior="rscfd";
        status_register="CFSTS5"; fifo_index=5; fifo_channel=1;
        access_widths="1,2,4";
        field { sw=r; reset=0; } value[31:0];
    } CFDF11_5 @ 0xFFD236B8;

    reg {
        regwidth=32; accesswidth=32; desc="RSCFD0CFDCFDF12_5 (CFID5 window +0x3C): CFIFO 5 unread-message data bytes 48..51; read-only in receive mode";
        evidence="manual"; source_ref="R01UH0585EJ0120 section 17.4.8.7, Tables 17.12 and 17.138 (page 1003); SFR list FFD236BC"; behavior="rscfd";
        status_register="CFSTS5"; fifo_index=5; fifo_channel=1;
        access_widths="1,2,4";
        field { sw=r; reset=0; } value[31:0];
    } CFDF12_5 @ 0xFFD236BC;

    reg {
        regwidth=32; accesswidth=32; desc="RSCFD0CFDCFDF13_5 (CFID5 window +0x40): CFIFO 5 unread-message data bytes 52..55; read-only in receive mode";
        evidence="manual"; source_ref="R01UH0585EJ0120 section 17.4.8.7, Tables 17.12 and 17.138 (page 1003); SFR list FFD236C0"; behavior="rscfd";
        status_register="CFSTS5"; fifo_index=5; fifo_channel=1;
        access_widths="1,2,4";
        field { sw=r; reset=0; } value[31:0];
    } CFDF13_5 @ 0xFFD236C0;

    reg {
        regwidth=32; accesswidth=32; desc="RSCFD0CFDCFDF14_5 (CFID5 window +0x44): CFIFO 5 unread-message data bytes 56..59; read-only in receive mode";
        evidence="manual"; source_ref="R01UH0585EJ0120 section 17.4.8.7, Tables 17.12 and 17.138 (page 1003); SFR list FFD236C4"; behavior="rscfd";
        status_register="CFSTS5"; fifo_index=5; fifo_channel=1;
        access_widths="1,2,4";
        field { sw=r; reset=0; } value[31:0];
    } CFDF14_5 @ 0xFFD236C4;

    reg {
        regwidth=32; accesswidth=32; desc="RSCFD0CFDCFDF15_5 (CFID5 window +0x48): CFIFO 5 unread-message data bytes 60..63; read-only in receive mode";
        evidence="manual"; source_ref="R01UH0585EJ0120 section 17.4.8.7, Tables 17.12 and 17.138 (page 1003); SFR list FFD236C8"; behavior="rscfd";
        status_register="CFSTS5"; fifo_index=5; fifo_channel=1;
        access_widths="1,2,4";
        field { sw=r; reset=0; } value[31:0];
    } CFDF15_5 @ 0xFFD236C8;

    reg {
        regwidth=32; accesswidth=32; desc="RSCFD0CFDGCFG: global configuration; CMPOC bit 5 payload-overflow mode (0 = frame whose payload exceeds storage size is not stored; 1 = stored with excess payload discarded), DRE bit 2 DLC replacement, ITRCP[31:16] interval-timer prescaler, TSBTCS[15:13]/TSSS bit 12/TSP[11:8] timestamp clock; reset 0x0";
        evidence="manual"; source_ref="R01UH0585EJ0120 Table 17.106, section 17.4.4.1 (pages 948-950); SFR list FFD20084"; behavior="rscfd";
        field { sw=rw; reset=0; } value[31:0];
    } GCFG @ 0xFFD20084;

    reg {
        regwidth=32; accesswidth=32; desc="RSCFD0CFDGCTR: global control; GSLPR bit 2 global stop, GMDC[1:0] bits 1-0 (00 global operating, 01 global reset, 10 global test); reset 0x5 (global reset with stop)";
        evidence="manual"; source_ref="R01UH0585EJ0120 Table 17.107, section 17.4.4.2 (page 952); SFR list FFD20088"; behavior="rscfd";
        field { sw=rw; reset=5; } value[31:0];
    } GCTR @ 0xFFD20088;

    reg {
        regwidth=32; accesswidth=32; desc="RSCFD0CFDGSTS: global status; GRAMINIT bit 3, GSLPSTS bit 2, GHLTSTS bit 1, GRSTSTS bit 0; reset 0xD";
        evidence="manual"; source_ref="R01UH0585EJ0120 section 17.4.4.3, Table 17.108 (pages 954-955)"; behavior="rscfd";
        access_widths="1,2,4";
        field { sw=r; reset=13; } value[31:0];
    } GSTS @ 0xFFD2008C;

    reg {
        regwidth=32; accesswidth=32; desc="RSCFD0CFDC1CTR (CmCTR = base+0x04+0x10*m, m=1): CAN1 channel control; CHMDC[1:0] bits 1-0 (00 channel communication, 01 channel reset, 10 channel halt), CSLPR bit 2 channel stop; reset 0x5 (channel reset and stop)";
        evidence="manual"; source_ref="R01UH0585EJ0120 Table 17.96, section 17.4.3.2 (pages 923-925); SFR list FFD20014"; behavior="rscfd";
        field { sw=rw; reset=5; } value[31:0];
    } C1CTR @ 0xFFD20014;

    reg {
        regwidth=32; accesswidth=32; desc="RSCFD0CFDC1STS (CmSTS = base+0x08+0x10*m, m=1): CAN1 channel status; TEC[31:24] and REC[23:16] error counters, ESIF bit 8, COMSTS bit 7, RECSTS bit 6, TRMSTS bit 5, BOSTS bit 4, EPSTS bit 3, CSLPSTS bit 2, CHLTSTS bit 1, CRSTSTS bit 0; reset 0x5 (channel stop + channel reset state); native diagnostic receive gate 0x83EF2 polls (C1STS & 7) == 0 before entering the CFIFO receive path";
        evidence="manual"; source_ref="R01UH0585EJ0120 Tables 17.12 and 17.97, section 17.4.3.3 (pages 797, 928-929); SFR list FFD20018; firmware table 0x22F6C stores this address; native gate 0x83EF2 masks with 7"; behavior="rscfd";
        access_widths="1,2,4";
        field { sw=rw; reset=5; } value[31:0];
    } C1STS @ 0xFFD20018;

    reg {
        regwidth=32; accesswidth=32; desc="RSCFD Tx message-buffer RAM base (0x20-byte entries)";
        evidence="manual"; source_ref="R01UH0585EJ0120 section 17, RSCFD register tables; firmware-observed role"; behavior="rscfd";
        access_widths="1,2,4";
        field { sw=rw; } value[31:0];
    } CFDTMID @ 0xFFD24000;

    reg {
        regwidth=32; accesswidth=32; desc="Diagnostic Tx message RAM for buffer n=16 (CAN 0x7A9 path)";
        evidence="manual"; source_ref="R01UH0585EJ0120 section 17, RSCFD register tables; firmware-observed role"; behavior="rscfd";
        access_widths="1,2,4";
        field { sw=rw; } value[31:0];
    } CFDTMID16 @ 0xFFD24200;

    reg {
        regwidth=32; accesswidth=32; desc="Diagnostic Tx buffer n=16 pointer/DLC word";
        evidence="manual"; source_ref="R01UH0585EJ0120 section 17, RSCFD Tx message-buffer RAM"; behavior="rscfd";
        access_widths="1,2,4";
        field { sw=rw; } value[31:0];
    } CFDTMPTR16 @ 0xFFD24204;

    reg {
        regwidth=32; accesswidth=32; desc="Diagnostic Tx buffer n=16 FD pointer/status word";
        evidence="manual"; source_ref="R01UH0585EJ0120 section 17, RSCFD Tx message-buffer RAM"; behavior="rscfd";
        access_widths="1,2,4";
        field { sw=rw; } value[31:0];
    } CFDTMFDSTS16 @ 0xFFD24208;

    reg {
        regwidth=32; accesswidth=32; desc="Diagnostic Tx buffer n=16 data bytes 0..3";
        evidence="manual"; source_ref="R01UH0585EJ0120 section 17, RSCFD Tx message-buffer RAM"; behavior="rscfd";
        access_widths="1,2,4";
        field { sw=rw; } value[31:0];
    } CFDTMDF0_16 @ 0xFFD2420C;

    reg {
        regwidth=32; accesswidth=32; desc="Diagnostic Tx buffer n=16 data bytes 4..7";
        evidence="manual"; source_ref="R01UH0585EJ0120 section 17, RSCFD Tx message-buffer RAM"; behavior="rscfd";
        access_widths="1,2,4";
        field { sw=rw; } value[31:0];
    } CFDTMDF1_16 @ 0xFFD24210;

    reg {
        regwidth=32; accesswidth=32; desc="Application CAN1 Tx message RAM buffer n=16 identifier";
        evidence="manual"; source_ref="R01UH0585EJ0120 section 17, RSCFD channel-1 Tx message-buffer RAM"; behavior="rscfd";
        access_widths="1,2,4";
        field { sw=rw; } value[31:0];
    } CFDTMID_CH1_16 @ 0xFFD24400;

    reg {
        regwidth=32; accesswidth=32; desc="Application CAN1 Tx message RAM buffer n=16 pointer/DLC word";
        evidence="manual"; source_ref="R01UH0585EJ0120 section 17, RSCFD channel-1 Tx message-buffer RAM"; behavior="rscfd";
        access_widths="1,2,4";
        field { sw=rw; } value[31:0];
    } CFDTMPTR_CH1_16 @ 0xFFD24404;

    reg {
        regwidth=32; accesswidth=32; desc="Application CAN1 Tx buffer n=16 FD pointer/status word";
        evidence="manual"; source_ref="R01UH0585EJ0120 section 17, RSCFD channel-1 Tx message-buffer RAM"; behavior="rscfd";
        access_widths="1,2,4";
        field { sw=rw; } value[31:0];
    } CFDTMFDSTS_CH1_16 @ 0xFFD24408;

    reg {
        regwidth=32; accesswidth=32; desc="Application CAN1 Tx buffer n=16 data bytes 0..3";
        evidence="manual"; source_ref="R01UH0585EJ0120 section 17, RSCFD channel-1 Tx message-buffer RAM"; behavior="rscfd";
        access_widths="1,2,4";
        field { sw=rw; } value[31:0];
    } CFDTMDF0_CH1_16 @ 0xFFD2440C;

    reg {
        regwidth=32; accesswidth=32; desc="Application CAN1 Tx buffer n=16 data bytes 4..7";
        evidence="manual"; source_ref="R01UH0585EJ0120 section 17, RSCFD channel-1 Tx message-buffer RAM"; behavior="rscfd";
        access_widths="1,2,4";
        field { sw=rw; } value[31:0];
    } CFDTMDF1_CH1_16 @ 0xFFD24410;

    reg {
        regwidth=8; accesswidth=8; desc="ECM master error-source set trigger";
        evidence="manual"; source_ref="R01UH0585EJ0120 register tables; firmware-observed role where stated"; behavior="storage";
        field { sw=w; } value[7:0];
    } ECMMESET @ 0xFFD60000;

    reg {
        regwidth=8; accesswidth=8; desc="ECM master error-source clear trigger";
        evidence="manual"; source_ref="R01UH0585EJ0120 register tables; firmware-observed role where stated"; behavior="storage";
        field { sw=w; } value[7:0];
    } ECMMECLR @ 0xFFD60004;

    reg {
        regwidth=32; accesswidth=32; desc="ECM master error-source status 0";
        evidence="manual"; source_ref="R01UH0585EJ0120 register tables; firmware-observed role where stated"; behavior="storage";
        field { sw=r; } value[31:0];
    } ECMMESSTR0 @ 0xFFD60008;

    reg {
        regwidth=32; accesswidth=32; desc="ECM master error-source status 1";
        evidence="manual"; source_ref="R01UH0585EJ0120 register tables; firmware-observed role where stated"; behavior="storage";
        field { sw=r; } value[31:0];
    } ECMMESSTR1 @ 0xFFD6000C;

    reg {
        regwidth=32; accesswidth=32; desc="ECM master error-source status 2";
        evidence="manual"; source_ref="R01UH0585EJ0120 register tables; firmware-observed role where stated"; behavior="storage";
        field { sw=r; } value[31:0];
    } ECMMESSTR2 @ 0xFFD60010;

    reg {
        regwidth=32; accesswidth=32; desc="ECM master protection command; write 0xA5 before protected writes";
        evidence="manual"; source_ref="R01UH0585EJ0120 register tables; firmware-observed role where stated"; behavior="storage";
        field { sw=w; } value[31:0];
    } ECMMPCMD0 @ 0xFFD60014;

    reg {
        regwidth=8; accesswidth=8; desc="ECM checker error-source set trigger";
        evidence="manual"; source_ref="R01UH0585EJ0120 register tables; firmware-observed role where stated"; behavior="storage";
        field { sw=w; } value[7:0];
    } ECMCESET @ 0xFFD61000;

    reg {
        regwidth=8; accesswidth=8; desc="ECM checker error-source clear trigger";
        evidence="manual"; source_ref="R01UH0585EJ0120 register tables; firmware-observed role where stated"; behavior="storage";
        field { sw=w; } value[7:0];
    } ECMCECLR @ 0xFFD61004;

    reg {
        regwidth=32; accesswidth=32; desc="ECM checker error-source status 0";
        evidence="manual"; source_ref="R01UH0585EJ0120 register tables; firmware-observed role where stated"; behavior="storage";
        field { sw=r; } value[31:0];
    } ECMCESSTR0 @ 0xFFD61008;

    reg {
        regwidth=32; accesswidth=32; desc="ECM checker error-source status 1";
        evidence="manual"; source_ref="R01UH0585EJ0120 register tables; firmware-observed role where stated"; behavior="storage";
        field { sw=r; } value[31:0];
    } ECMCESSTR1 @ 0xFFD6100C;

    reg {
        regwidth=32; accesswidth=32; desc="ECM checker error-source status 2";
        evidence="manual"; source_ref="R01UH0585EJ0120 register tables; firmware-observed role where stated"; behavior="storage";
        field { sw=r; } value[31:0];
    } ECMCESSTR2 @ 0xFFD61010;

    reg {
        regwidth=32; accesswidth=32; desc="ECM checker protection command; write 0xA5 before protected writes";
        evidence="manual"; source_ref="R01UH0585EJ0120 register tables; firmware-observed role where stated"; behavior="storage";
        field { sw=w; } value[31:0];
    } ECMCPCMD0 @ 0xFFD61014;

    reg {
        regwidth=8; accesswidth=8; desc="ECM error-pulse configuration";
        evidence="manual"; source_ref="R01UH0585EJ0120 register tables; firmware-observed role where stated"; behavior="storage";
        field { sw=rw; } value[7:0];
    } ECMEPCFG @ 0xFFD62000;

    reg {
        regwidth=32; accesswidth=32; desc="ECM maskable-interrupt configuration 0";
        evidence="manual"; source_ref="R01UH0585EJ0120 register tables; firmware-observed role where stated"; behavior="storage";
        field { sw=rw; } value[31:0];
    } ECMMICFG0 @ 0xFFD62004;

    reg {
        regwidth=32; accesswidth=32; desc="ECM maskable-interrupt configuration 1";
        evidence="manual"; source_ref="R01UH0585EJ0120 register tables; firmware-observed role where stated"; behavior="storage";
        field { sw=rw; } value[31:0];
    } ECMMICFG1 @ 0xFFD62008;

    reg {
        regwidth=32; accesswidth=32; desc="ECM maskable-interrupt configuration 2";
        evidence="manual"; source_ref="R01UH0585EJ0120 register tables; firmware-observed role where stated"; behavior="storage";
        field { sw=rw; } value[31:0];
    } ECMMICFG2 @ 0xFFD6200C;

    reg {
        regwidth=32; accesswidth=32; desc="ECM non-maskable-interrupt configuration 0";
        evidence="manual"; source_ref="R01UH0585EJ0120 register tables; firmware-observed role where stated"; behavior="storage";
        field { sw=rw; } value[31:0];
    } ECMNMICFG0 @ 0xFFD62010;

    reg {
        regwidth=32; accesswidth=32; desc="ECM non-maskable-interrupt configuration 1";
        evidence="manual"; source_ref="R01UH0585EJ0120 register tables; firmware-observed role where stated"; behavior="storage";
        field { sw=rw; } value[31:0];
    } ECMNMICFG1 @ 0xFFD62014;

    reg {
        regwidth=32; accesswidth=32; desc="ECM non-maskable-interrupt configuration 2";
        evidence="manual"; source_ref="R01UH0585EJ0120 register tables; firmware-observed role where stated"; behavior="storage";
        field { sw=rw; } value[31:0];
    } ECMNMICFG2 @ 0xFFD62018;

    reg {
        regwidth=32; accesswidth=32; desc="ECM internal-reset configuration 0";
        evidence="manual"; source_ref="R01UH0585EJ0120 register tables; firmware-observed role where stated"; behavior="storage";
        field { sw=rw; } value[31:0];
    } ECMIRCFG0 @ 0xFFD6201C;

    reg {
        regwidth=32; accesswidth=32; desc="ECM internal-reset configuration 1";
        evidence="manual"; source_ref="R01UH0585EJ0120 register tables; firmware-observed role where stated"; behavior="storage";
        field { sw=rw; } value[31:0];
    } ECMIRCFG1 @ 0xFFD62020;

    reg {
        regwidth=32; accesswidth=32; desc="ECM internal-reset configuration 2";
        evidence="manual"; source_ref="R01UH0585EJ0120 register tables; firmware-observed role where stated"; behavior="storage";
        field { sw=rw; } value[31:0];
    } ECMIRCFG2 @ 0xFFD62024;

    reg {
        regwidth=32; accesswidth=32; desc="ECM error mask 0";
        evidence="manual"; source_ref="R01UH0585EJ0120 register tables; firmware-observed role where stated"; behavior="storage";
        field { sw=rw; } value[31:0];
    } ECMEMK0 @ 0xFFD62028;

    reg {
        regwidth=32; accesswidth=32; desc="ECM error mask 1";
        evidence="manual"; source_ref="R01UH0585EJ0120 register tables; firmware-observed role where stated"; behavior="storage";
        field { sw=rw; } value[31:0];
    } ECMEMK1 @ 0xFFD6202C;

    reg {
        regwidth=32; accesswidth=32; desc="ECM error mask 2";
        evidence="manual"; source_ref="R01UH0585EJ0120 register tables; firmware-observed role where stated"; behavior="storage";
        field { sw=rw; } value[31:0];
    } ECMEMK2 @ 0xFFD62030;

    reg {
        regwidth=32; accesswidth=32; desc="ECM error-source status-clear trigger 0";
        evidence="manual"; source_ref="R01UH0585EJ0120 register tables; firmware-observed role where stated"; behavior="storage";
        field { sw=w; } value[31:0];
    } ECMESSTC0 @ 0xFFD62034;

    reg {
        regwidth=32; accesswidth=32; desc="ECM error-source status-clear trigger 1";
        evidence="manual"; source_ref="R01UH0585EJ0120 register tables; firmware-observed role where stated"; behavior="storage";
        field { sw=w; } value[31:0];
    } ECMESSTC1 @ 0xFFD62038;

    reg {
        regwidth=32; accesswidth=32; desc="ECM error-source status-clear trigger 2";
        evidence="manual"; source_ref="R01UH0585EJ0120 register tables; firmware-observed role where stated"; behavior="storage";
        field { sw=w; } value[31:0];
    } ECMESSTC2 @ 0xFFD6203C;

    reg {
        regwidth=32; accesswidth=32; desc="ECM common protection command; write 0xA5 before protected writes";
        evidence="manual"; source_ref="R01UH0585EJ0120 register tables; firmware-observed role where stated"; behavior="storage";
        field { sw=w; } value[31:0];
    } ECMPCMD1 @ 0xFFD62040;

    reg {
        regwidth=8; accesswidth=8; desc="ECM common protection status";
        evidence="manual"; source_ref="R01UH0585EJ0120 register tables; firmware-observed role where stated"; behavior="storage";
        field { sw=r; } value[7:0];
    } ECMPS @ 0xFFD62044;

    reg {
        regwidth=32; accesswidth=32; desc="ECM pseudo-error trigger 0";
        evidence="manual"; source_ref="R01UH0585EJ0120 register tables; firmware-observed role where stated"; behavior="storage";
        field { sw=w; } value[31:0];
    } ECMPE0 @ 0xFFD62048;

    reg {
        regwidth=32; accesswidth=32; desc="ECM pseudo-error trigger 1";
        evidence="manual"; source_ref="R01UH0585EJ0120 register tables; firmware-observed role where stated"; behavior="storage";
        field { sw=w; } value[31:0];
    } ECMPE1 @ 0xFFD6204C;

    reg {
        regwidth=32; accesswidth=32; desc="ECM pseudo-error trigger 2";
        evidence="manual"; source_ref="R01UH0585EJ0120 register tables; firmware-observed role where stated"; behavior="storage";
        field { sw=w; } value[31:0];
    } ECMPE2 @ 0xFFD62050;

    reg {
        regwidth=8; accesswidth=8; desc="ECM delay-timer control";
        evidence="manual"; source_ref="R01UH0585EJ0120 register tables; firmware-observed role where stated"; behavior="storage";
        field { sw=rw; } value[7:0];
    } ECMDTMCTL @ 0xFFD62054;

    reg {
        regwidth=16; accesswidth=16; desc="ECM delay-timer count";
        evidence="manual"; source_ref="R01UH0585EJ0120 register tables; firmware-observed role where stated"; behavior="storage";
        field { sw=r; } value[15:0];
    } ECMDTMR @ 0xFFD62058;

    reg {
        regwidth=32; accesswidth=32; desc="ECM delay-timer compare";
        evidence="manual"; source_ref="R01UH0585EJ0120 register tables; firmware-observed role where stated"; behavior="storage";
        field { sw=rw; } value[31:0];
    } ECMDTMCMP @ 0xFFD6205C;

    reg {
        regwidth=32; accesswidth=32; desc="ECM delay-timer configuration 0";
        evidence="manual"; source_ref="R01UH0585EJ0120 register tables; firmware-observed role where stated"; behavior="storage";
        field { sw=rw; } value[31:0];
    } ECMDTMCFG0 @ 0xFFD62060;

    reg {
        regwidth=32; accesswidth=32; desc="ECM delay-timer configuration 1";
        evidence="manual"; source_ref="R01UH0585EJ0120 register tables; firmware-observed role where stated"; behavior="storage";
        field { sw=rw; } value[31:0];
    } ECMDTMCFG1 @ 0xFFD62064;

    reg {
        regwidth=32; accesswidth=32; desc="ECM delay-timer configuration 2";
        evidence="manual"; source_ref="R01UH0585EJ0120 register tables; firmware-observed role where stated"; behavior="storage";
        field { sw=rw; } value[31:0];
    } ECMDTMCFG2 @ 0xFFD62068;

    reg {
        regwidth=32; accesswidth=32; desc="ECM delay-timer configuration 3";
        evidence="manual"; source_ref="R01UH0585EJ0120 register tables; firmware-observed role where stated"; behavior="storage";
        field { sw=rw; } value[31:0];
    } ECMDTMCFG3 @ 0xFFD6206C;

    reg {
        regwidth=32; accesswidth=32; desc="ECM delay-timer configuration 4";
        evidence="manual"; source_ref="R01UH0585EJ0120 register tables; firmware-observed role where stated"; behavior="storage";
        field { sw=rw; } value[31:0];
    } ECMDTMCFG4 @ 0xFFD62070;

    reg {
        regwidth=32; accesswidth=32; desc="ECM delay-timer configuration 5";
        evidence="manual"; source_ref="R01UH0585EJ0120 register tables; firmware-observed role where stated"; behavior="storage";
        field { sw=rw; } value[31:0];
    } ECMDTMCFG5 @ 0xFFD62074;

    reg {
        regwidth=32; accesswidth=32; desc="ECM error-output clear-invalidation configuration";
        evidence="manual"; source_ref="R01UH0585EJ0120 register tables; firmware-observed role where stated"; behavior="storage";
        field { sw=rw; } value[31:0];
    } ECMEOCCFG @ 0xFFD62078;

    reg {
        regwidth=32; accesswidth=32; desc="ECM pseudo-error mask";
        evidence="manual"; source_ref="R01UH0585EJ0120 register tables; firmware-observed role where stated"; behavior="storage";
        field { sw=rw; } value[31:0];
    } ECMPEM @ 0xFFD6207C;

    reg {
        regwidth=8; accesswidth=8; desc="ECM error-pulse control";
        evidence="manual"; source_ref="R01UH0585EJ0120 register tables; firmware-observed role where stated"; behavior="storage";
        field { sw=rw; } value[7:0];
    } ECMEPCTL @ 0xFFD63000;

    reg {
        regwidth=32; accesswidth=32; desc="TAUJ0 channel 0 data reload";
        evidence="manual"; source_ref="R01UH0585EJ0120 section 24.3"; behavior="tauj";
        field { sw=rw; } value[31:0];
    } TAUJ0CDR0 @ 0xFFE50000;

    reg {
        regwidth=32; accesswidth=32; desc="TAUJ0 channel 1 data reload";
        evidence="manual"; source_ref="R01UH0585EJ0120 section 24.3"; behavior="tauj";
        field { sw=rw; } value[31:0];
    } TAUJ0CDR1 @ 0xFFE50004;

    reg {
        regwidth=32; accesswidth=32; desc="TAUJ0 channel 2 data reload";
        evidence="manual"; source_ref="R01UH0585EJ0120 section 24.3"; behavior="tauj";
        field { sw=rw; } value[31:0];
    } TAUJ0CDR2 @ 0xFFE50008;

    reg {
        regwidth=32; accesswidth=32; desc="TAUJ0 channel 3 data reload";
        evidence="manual"; source_ref="R01UH0585EJ0120 section 24.3"; behavior="tauj";
        field { sw=rw; } value[31:0];
    } TAUJ0CDR3 @ 0xFFE5000C;

    reg {
        regwidth=32; accesswidth=32; desc="TAUJ0 channel 0 counter";
        evidence="manual"; source_ref="R01UH0585EJ0120 section 24.3"; behavior="tauj";
        field { sw=r; } value[31:0];
    } TAUJ0CNT0 @ 0xFFE50010;

    reg {
        regwidth=32; accesswidth=32; desc="TAUJ0 channel 1 counter";
        evidence="manual"; source_ref="R01UH0585EJ0120 section 24.3"; behavior="tauj";
        field { sw=r; } value[31:0];
    } TAUJ0CNT1 @ 0xFFE50014;

    reg {
        regwidth=32; accesswidth=32; desc="TAUJ0 channel 2 counter";
        evidence="manual"; source_ref="R01UH0585EJ0120 section 24.3"; behavior="tauj";
        field { sw=r; } value[31:0];
    } TAUJ0CNT2 @ 0xFFE50018;

    reg {
        regwidth=32; accesswidth=32; desc="TAUJ0 channel 3 counter";
        evidence="manual"; source_ref="R01UH0585EJ0120 section 24.3"; behavior="tauj";
        field { sw=r; } value[31:0];
    } TAUJ0CNT3 @ 0xFFE5001C;

    reg {
        regwidth=8; accesswidth=8; desc="TAUJ0 channel 0 user mode";
        evidence="manual"; source_ref="R01UH0585EJ0120 Table 24.10"; behavior="tauj";
        field { sw=rw; } value[7:0];
    } TAUJ0CMUR0 @ 0xFFE50020;

    reg {
        regwidth=8; accesswidth=8; desc="TAUJ0 channel 1 user mode";
        evidence="manual"; source_ref="R01UH0585EJ0120 Table 24.10"; behavior="tauj";
        field { sw=rw; } value[7:0];
    } TAUJ0CMUR1 @ 0xFFE50024;

    reg {
        regwidth=8; accesswidth=8; desc="TAUJ0 channel 2 user mode";
        evidence="manual"; source_ref="R01UH0585EJ0120 Table 24.10"; behavior="tauj";
        field { sw=rw; } value[7:0];
    } TAUJ0CMUR2 @ 0xFFE50028;

    reg {
        regwidth=8; accesswidth=8; desc="TAUJ0 channel 3 user mode";
        evidence="manual"; source_ref="R01UH0585EJ0120 Table 24.10"; behavior="tauj";
        field { sw=rw; } value[7:0];
    } TAUJ0CMUR3 @ 0xFFE5002C;

    reg {
        regwidth=8; accesswidth=8; desc="TAUJ0 channel enable status";
        evidence="manual"; source_ref="R01UH0585EJ0120 Table 24.10"; behavior="tauj";
        field { sw=r; reset=0; } value[7:0];
    } TAUJ0TE @ 0xFFE50050;

    reg {
        regwidth=8; accesswidth=8; desc="TAUJ0 channel start trigger";
        evidence="manual"; source_ref="R01UH0585EJ0120 Table 24.10; sections 24.3 and 24.12.1"; behavior="tauj";
        trigger="tauj-start"; status_register="TAUJ0TE"; reload_prefix="TAUJ0CDR"; counter_prefix="TAUJ0CNT"; channel_count=4;
        interrupt_register_prefix="EIC"; interrupt_channel_base=133; mode_prefix="TAUJ0CMOR"; prescaler_register="TAUJ0TPS";
        field { sw=w; } value[7:0];
    } TAUJ0TS @ 0xFFE50054;

    reg {
        regwidth=8; accesswidth=8; desc="TAUJ0 channel stop trigger";
        evidence="manual"; source_ref="R01UH0585EJ0120 Table 24.10; sections 24.3 and 24.12.1"; behavior="tauj";
        trigger="tauj-stop"; status_register="TAUJ0TE"; reload_prefix="TAUJ0CDR"; counter_prefix="TAUJ0CNT"; channel_count=4;
        interrupt_register_prefix="EIC"; interrupt_channel_base=133; mode_prefix="TAUJ0CMOR"; prescaler_register="TAUJ0TPS";
        field { sw=w; } value[7:0];
    } TAUJ0TT @ 0xFFE50058;

    reg {
        regwidth=8; accesswidth=8; desc="TAUJ0 channel output";
        evidence="manual"; source_ref="R01UH0585EJ0120 Table 24.10"; behavior="tauj";
        field { sw=rw; reset=0; } value[7:0];
    } TAUJ0TO @ 0xFFE5005C;

    reg {
        regwidth=8; accesswidth=8; desc="TAUJ0 channel output enable";
        evidence="manual"; source_ref="R01UH0585EJ0120 Table 24.10"; behavior="tauj";
        field { sw=rw; reset=0; } value[7:0];
    } TAUJ0TOE @ 0xFFE50060;

    reg {
        regwidth=8; accesswidth=8; desc="TAUJ0 channel output active level";
        evidence="manual"; source_ref="R01UH0585EJ0120 Table 24.10"; behavior="tauj";
        field { sw=rw; reset=0; } value[7:0];
    } TAUJ0TOL @ 0xFFE50064;

    reg {
        regwidth=8; accesswidth=8; desc="TAUJ0 channel reload data trigger";
        evidence="manual"; source_ref="R01UH0585EJ0120 Table 24.10"; behavior="tauj";
        field { sw=w; } value[7:0];
    } TAUJ0RDT @ 0xFFE50068;

    reg {
        regwidth=8; accesswidth=8; desc="TAUJ0 channel reload status";
        evidence="manual"; source_ref="R01UH0585EJ0120 Table 24.10"; behavior="tauj";
        field { sw=r; reset=0; } value[7:0];
    } TAUJ0RSF @ 0xFFE5006C;

    reg {
        regwidth=16; accesswidth=16; desc="TAUJ0 channel 0 mode";
        evidence="manual"; source_ref="R01UH0585EJ0120 section 24.3"; behavior="tauj";
        field { sw=rw; } value[15:0];
    } TAUJ0CMOR0 @ 0xFFE50080;

    reg {
        regwidth=16; accesswidth=16; desc="TAUJ0 channel 1 mode";
        evidence="manual"; source_ref="R01UH0585EJ0120 section 24.3"; behavior="tauj";
        field { sw=rw; } value[15:0];
    } TAUJ0CMOR1 @ 0xFFE50084;

    reg {
        regwidth=16; accesswidth=16; desc="TAUJ0 channel 2 mode";
        evidence="manual"; source_ref="R01UH0585EJ0120 section 24.3"; behavior="tauj";
        field { sw=rw; } value[15:0];
    } TAUJ0CMOR2 @ 0xFFE50088;

    reg {
        regwidth=16; accesswidth=16; desc="TAUJ0 channel 3 mode";
        evidence="manual"; source_ref="R01UH0585EJ0120 section 24.3"; behavior="tauj";
        field { sw=rw; } value[15:0];
    } TAUJ0CMOR3 @ 0xFFE5008C;

    reg {
        regwidth=16; accesswidth=16; desc="TAUJ0 prescaler";
        evidence="manual"; source_ref="R01UH0585EJ0120 section 24.3"; behavior="tauj";
        field { sw=rw; } value[15:0];
    } TAUJ0TPS @ 0xFFE50090;

    reg {
        regwidth=16; accesswidth=16; desc="TAUJ0 base-clock reload selector";
        evidence="manual"; source_ref="R01UH0585EJ0120 section 24.3"; behavior="tauj";
        access_widths="1,2";
        field { sw=rw; } value[15:0];
    } TAUJ0BRS @ 0xFFE50094;

    reg {
        regwidth=8; accesswidth=8; desc="TAUJ0 channel reload data enable";
        evidence="manual"; source_ref="R01UH0585EJ0120 Table 24.10"; behavior="tauj";
        field { sw=rw; reset=0; } value[7:0];
    } TAUJ0RDE @ 0xFFE500A0;

    reg {
        regwidth=8; accesswidth=8; desc="TAUJ0 channel reload data mode";
        evidence="manual"; source_ref="R01UH0585EJ0120 Table 24.10"; behavior="tauj";
        field { sw=rw; reset=0; } value[7:0];
    } TAUJ0RDM @ 0xFFE500A4;

    reg {
        regwidth=32; accesswidth=32; desc="TSG30 bit-extended HT-PWM W-phase compare register";
        evidence="manual"; source_ref="R01UH0585EJ0120 register tables; firmware-observed role where stated"; behavior="storage";
        field { sw=rw; } value[31:0];
    } TSG30CMPWE @ 0xFFE70180;

    reg {
        regwidth=32; accesswidth=32; desc="TSG30 bit-extended HT-PWM V-phase compare register";
        evidence="manual"; source_ref="R01UH0585EJ0120 register tables; firmware-observed role where stated"; behavior="storage";
        field { sw=rw; } value[31:0];
    } TSG30CMPVE @ 0xFFE70184;

    reg {
        regwidth=32; accesswidth=32; desc="TSG30 bit-extended HT-PWM U-phase compare register";
        evidence="manual"; source_ref="R01UH0585EJ0120 register tables; firmware-observed role where stated"; behavior="storage";
        field { sw=rw; } value[31:0];
    } TSG30CMPUE @ 0xFFE70188;

    reg {
        regwidth=32; accesswidth=32; desc="TSG31 bit-extended HT-PWM W-phase compare register";
        evidence="manual"; source_ref="R01UH0585EJ0120 register tables; firmware-observed role where stated"; behavior="storage";
        field { sw=rw; } value[31:0];
    } TSG31CMPWE @ 0xFFE71180;

    reg {
        regwidth=32; accesswidth=32; desc="TSG31 bit-extended HT-PWM V-phase compare register";
        evidence="manual"; source_ref="R01UH0585EJ0120 register tables; firmware-observed role where stated"; behavior="storage";
        field { sw=rw; } value[31:0];
    } TSG31CMPVE @ 0xFFE71184;

    reg {
        regwidth=32; accesswidth=32; desc="TSG31 bit-extended HT-PWM U-phase compare register";
        evidence="manual"; source_ref="R01UH0585EJ0120 register tables; firmware-observed role where stated"; behavior="storage";
        field { sw=rw; } value[31:0];
    } TSG31CMPUE @ 0xFFE71188;

    reg {
        regwidth=32; accesswidth=32; desc="RAM initialization mode control for Global RAM; reset value 0x00000003";
        evidence="manual"; source_ref="R01UH0585EJ0120 sections 8.3.7-8.3.8"; behavior="reset_stac";
        field { sw=rw; reset=3; } value[31:0];
    } STAC_GRAM @ 0xFFF81420;

    reg {
        regwidth=32; accesswidth=32; desc="RAM initialization mode control for Local RAM; reset value 0x00000003";
        evidence="manual"; source_ref="R01UH0585EJ0120 sections 8.3.7-8.3.8"; behavior="reset_stac";
        field { sw=rw; reset=3; } value[31:0];
    } STAC_LM0 @ 0xFFF81520;

    reg {
        regwidth=32; accesswidth=32; desc="EXTCLK1O divider; boot writes 0x50 for divide by 80";
        evidence="manual"; source_ref="R01UH0585EJ0120 register tables; firmware-observed role where stated"; behavior="storage";
        field { sw=rw; } value[31:0];
    } CLKD3DIV @ 0xFFF88818;

    reg {
        regwidth=32; accesswidth=32; desc="EXTCLK1O divider status; boot polls synchronization and active state";
        evidence="manual"; source_ref="R01UH0585EJ0120 register tables; firmware-observed role where stated"; behavior="storage";
        field { sw=r; } value[31:0];
    } CLKD3STAT @ 0xFFF8881C;

    reg {
        regwidth=32; accesswidth=32; desc="EXTCLK1O source selector; source 4 is CLK_LSB";
        evidence="manual"; source_ref="R01UH0585EJ0120 register tables; firmware-observed role where stated"; behavior="storage";
        field { sw=rw; } value[31:0];
    } CKSC3C @ 0xFFF890C0;

    reg {
        regwidth=32; accesswidth=32; desc="EXTCLK1O selected-source status; boot polls until source 4 is active";
        evidence="manual"; source_ref="R01UH0585EJ0120 register tables; firmware-observed role where stated"; behavior="storage";
        field { sw=r; } value[31:0];
    } CKSC3S @ 0xFFF890C8;

    reg {
        regwidth=32; accesswidth=32; desc="ADCG0 data supplementary information register 00; DMA source for sample ring";
        evidence="manual"; source_ref="R01UH0585EJ0120 register tables; firmware-observed role where stated"; behavior="storage";
        field { sw=r; } value[31:0];
    } ADCG0DIR00 @ 0xFFF91200;

    reg {
        regwidth=32; accesswidth=32; desc="ADCG1 data supplementary information register 00; DMA source for sample ring";
        evidence="manual"; source_ref="R01UH0585EJ0120 register tables; firmware-observed role where stated"; behavior="storage";
        field { sw=r; } value[31:0];
    } ADCG1DIR00 @ 0xFFF92200;

    reg {
        regwidth=32; accesswidth=32; desc="DMAC0 channel 0 channel master setting register";
        evidence="manual"; source_ref="R01UH0585EJ0120 register tables; firmware-observed role where stated"; behavior="storage";
        field { sw=rw; } value[31:0];
    } DM00CM @ 0xFFFF8100;

    reg {
        regwidth=32; accesswidth=32; desc="DMAC1 channel 0 channel master setting register";
        evidence="manual"; source_ref="R01UH0585EJ0120 register tables; firmware-observed role where stated"; behavior="storage";
        field { sw=rw; } value[31:0];
    } DM10CM @ 0xFFFF8120;

    reg {
        regwidth=16; accesswidth=16; desc="ECM maskable-error interrupt control (EIINT 8); EIRF bit 12, EIMK bit 7, EITB bit 6, EIP[3:0], EICT bit 15; synchronous edge detection";
        evidence="manual"; source_ref="R01UH0585EJ0120 section 6.2.2 Table 6.4, Table 6.11; SFR list FFFEEA10"; behavior="intc_eic";
        interrupt_channel=8;
        access_widths="1,2";
        field { sw=rw; reset=0x8F; } value[15:0];
    } EIC8 @ 0xFFFEEA10;

    reg {
        regwidth=16; accesswidth=16; desc="TAUJ0 CH0 interrupt control (EIINT 133, INTTAUJ0I0); synchronous edge detection: EIRF bit 12 auto-cleared on CPU acceptance; source code 0x1085, INTBP offset +214H";
        evidence="manual"; source_ref="R01UH0585EJ0120 section 6.2.2 Table 6.4, Table 6.11"; behavior="intc_eic";
        interrupt_channel=133;
        access_widths="1,2";
        field { sw=rw; reset=0x8F; } value[15:0];
    } EIC133 @ 0xFFFFB10A;

    reg {
        regwidth=16; accesswidth=16; desc="TAUJ0 CH1 interrupt control (EIINT 134, INTTAUJ0I1); synchronous edge detection; source code 0x1086, INTBP offset +218H";
        evidence="manual"; source_ref="R01UH0585EJ0120 section 6.2.2 Table 6.4, Table 6.11"; behavior="intc_eic";
        interrupt_channel=134;
        access_widths="1,2";
        field { sw=rw; reset=0x8F; } value[15:0];
    } EIC134 @ 0xFFFFB10C;

    reg {
        regwidth=16; accesswidth=16; desc="TAUJ0 CH2 interrupt control (EIINT 135, INTTAUJ0I2); synchronous edge detection; source code 0x1087, INTBP offset +21CH";
        evidence="manual"; source_ref="R01UH0585EJ0120 section 6.2.2 Table 6.4, Table 6.11"; behavior="intc_eic";
        interrupt_channel=135;
        access_widths="1,2";
        field { sw=rw; reset=0x8F; } value[15:0];
    } EIC135 @ 0xFFFFB10E;

    reg {
        regwidth=16; accesswidth=16; desc="TAUJ0 CH3 interrupt control (EIINT 136, INTTAUJ0I3; foreground tick; EIRF bit 12 polled); synchronous edge detection; source code 0x1088, INTBP offset +220H";
        evidence="manual"; source_ref="R01UH0585EJ0120 section 6.2.2 Table 6.4, Table 6.11"; behavior="intc_eic";
        interrupt_channel=136;
        access_widths="1,2";
        field { sw=rw; reset=0x8F; } value[15:0];
    } EIC136 @ 0xFFFFB110;

    reg {
        regwidth=16; accesswidth=16; desc="RSCFD CAN1 transmit/receive-FIFO receive-completion interrupt control (EIINT 187, INTRCAN1REC; CFIFO receive path); high-level detection: EIRF bit 12 read-only, follows CFRXIF gated by CFRXIE, not cleared by acceptance; source code 0x10BB, INTBP offset +2ECH";
        evidence="manual"; source_ref="R01UH0585EJ0120 section 6.2.2 Table 6.4, Tables 6.11 and 17.8"; behavior="intc_eic";
        interrupt_channel=187;
        access_widths="1,2";
        field { sw=rw; reset=0x808F; } value[15:0];
    } EIC187 @ 0xFFFFB176;

    reg {
        regwidth=16; accesswidth=16; desc="RSCFD CAN1 transmit interrupt control (EIINT 188, INTRCAN1TRX); high-level detection: EIRF bit 12 read-only; source code 0x10BC, INTBP offset +2F0H";
        evidence="manual"; source_ref="R01UH0585EJ0120 section 6.2.2 Table 6.4, Tables 6.11 and 17.8"; behavior="intc_eic";
        interrupt_channel=188;
        access_widths="1,2";
        field { sw=rw; reset=0x808F; } value[15:0];
    } EIC188 @ 0xFFFFB178;

    reg {
        regwidth=16; accesswidth=16; desc="EIINT 292 interrupt control; channel reserved in Table 6.11 (no peripheral source documented); bound to the exact-firmware crypto driver; no manual reset row exists";
        evidence="manual"; source_ref="R01UH0585EJ0120 section 6.2.2 Table 6.4, Table 6.11 (reserved channel 292)"; behavior="intc_eic";
        interrupt_channel=292;
        access_widths="1,2";
        field { sw=rw; } value[15:0];
    } EIC292 @ 0xFFFFB248;

    reg {
        regwidth=16; accesswidth=16; desc="EIINT 293 interrupt control; channel reserved in Table 6.11 (no peripheral source documented); bound to the exact-firmware crypto driver; no manual reset row exists";
        evidence="manual"; source_ref="R01UH0585EJ0120 section 6.2.2 Table 6.4, Table 6.11 (reserved channel 293)"; behavior="intc_eic";
        interrupt_channel=293;
        access_widths="1,2";
        field { sw=rw; } value[15:0];
    } EIC293 @ 0xFFFFB24A;

    reg {
        regwidth=16; accesswidth=16; desc="Flash sequencer-end interrupt control (EIINT 379, INTFLENDNM); synchronous edge detection; source code 0x117B, INTBP offset +5ECH";
        evidence="manual"; source_ref="R01UH0585EJ0120 section 6.2.2 Table 6.4, Table 6.11; SFR list FFFFB2F6"; behavior="intc_eic";
        interrupt_channel=379;
        access_widths="1,2";
        field { sw=rw; reset=0x8F; } value[15:0];
    } EIC379 @ 0xFFFFB2F6;
};
