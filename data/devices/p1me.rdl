// Canonical RH850/P1M-E executable device description.
// Register descriptions migrated from data/p1m_sfr_labels.csv; that CSV is now a generated projection.
property evidence { type = string; component = addrmap | mem | reg; };
property source_ref { type = string; component = addrmap | mem | reg; };
property behavior { type = string; component = reg; };
property executable { type = boolean; component = mem; };
property access_widths { type = string; component = reg; };
property alias_group { type = string; component = mem; };
property reset_policy { type = string; component = mem; };
property product_ids { type = string; component = addrmap; };
property p_bus_hz { type = longint unsigned; component = addrmap; };
property trigger { type = string; component = reg; };
property writable_mask { type = longint unsigned; component = reg; };
property read_value { type = longint unsigned; component = reg; };
property read_input { type = boolean; component = reg; };
property sync_mask { type = longint unsigned; component = reg; };
property active_mask { type = longint unsigned; component = reg; };
property allowed_values { type = string; component = reg; };
property status_register { type = string; component = reg; };
property secondary_status_register { type = string; component = reg; };
property capture_registers { type = string; component = reg; };
property status_masks { type = string; component = reg; };
property secondary_status_masks { type = string; component = reg; };
property protection_mask { type = longint unsigned; component = reg; };
property protection_value { type = longint unsigned; component = reg; };
property access_register { type = string; component = reg; };
property history_register { type = string; component = reg; };
property start_address_register { type = string; component = reg; };
property end_address_register { type = string; component = reg; };
property mode_register { type = string; component = reg; };
property emulation_register { type = string; component = reg; };
property enable_register { type = string; component = reg; };
property secondary_enable_register { type = string; component = reg; };
property interrupt_channel { type = longint unsigned; component = reg; };
property interrupt_register { type = string; component = reg; };
property interrupt_channel_base { type = longint unsigned; component = reg; };
property control_register { type = string; component = reg; };
property pointer_register { type = string; component = reg; };
property window_register { type = string; component = reg; };
property channel_control_register { type = string; component = reg; };
property global_control_register { type = string; component = reg; };
property fifo_index { type = longint unsigned; component = reg; };
property fifo_channel { type = longint unsigned; component = reg; };
property payload_address { type = longint unsigned; component = reg; };
property completion_value { type = longint unsigned; component = reg; };
property reset_control { type = string; component = mem; };
property reset_rules { type = string; component = mem; };
property reset_classes { type = string; component = reg; };
property skipped_value { type = longint unsigned; component = reg; };
property reset_mask { type = longint unsigned; component = reg; };

reg peripheral_ecc_control {
    regwidth=32; accesswidth=32;
    desc="Peripheral RAM ECC control, latched error flags and live ECEMF input";
    evidence="manual"; source_ref="R01UH0585EJ0120 Tables31.76-31.79; AppendixA pp2963-2964";
    behavior="peripheral-ecc"; trigger="peripheral-ecc-control";
    writable_mask=0xC6B8; reset_mask=0xFFFFFFFE;
    reset_classes="power-on,system-1-cvm,system-1-pin,system-2,application-1";
    field { sw=rw; reset=0x10; } value[31:0];
};

reg peripheral_ecc_test {
    regwidth=32; accesswidth=32;
    desc="Peripheral RAM ECC test control; ETMA=10 authorizes the mode bit";
    evidence="manual"; source_ref="R01UH0585EJ0120 Tables31.76-31.78,31.80; AppendixA pp2963-2964";
    behavior="peripheral-ecc"; trigger="peripheral-ecc-test"; writable_mask=0xC09F;
    reset_classes="power-on,system-1-cvm,system-1-pin,system-2,application-1";
    field { sw=rw; reset=0; } value[31:0];
};

addrmap p1me {
    desc = "Renesas RH850/P1M-E R7F701381/R7F701383 functional machine model";
    evidence = "manual";
    source_ref = "R01UH0585EJ0120 Rev.1.20; R01UH0615EJ0120 Rev.1.20; R01US0123EJ0140 Rev.1.40";
    product_ids = "R7F701381,R7F701383";
    p_bus_hz = 80000000;

    // Section7 DMASS: DMACTL bit0 suspends transfers; it is not an enable bit.
    reg pdma_word_t {
        regwidth=32; accesswidth=32; behavior="pdma"; writable_mask=0xFFFFFFFF;
        evidence="manual"; source_ref="R01UH0585EJ0120 Tables7.15,7.46-7.61";
        reset_classes="power-on,system-1-cvm,system-1-pin,system-2,application-1";
        field { sw=rw; reset=0; } value[31:0];
    };
    reg pdma_status_t {
        regwidth=32; accesswidth=32; behavior="pdma";
        evidence="manual"; source_ref="R01UH0585EJ0120 Tables7.20,7.23,7.24,7.27,7.56,7.60";
        reset_classes="power-on,system-1-cvm,system-1-pin,system-2,application-1";
        field { sw=r; reset=0; } value[31:0];
    };
    reg pdma_master_t {
        regwidth=32; accesswidth=32; behavior="pdma"; writable_mask=0xE07E;
        evidence="manual"; source_ref="R01UH0585EJ0120 section7.6 Table7.44";
        reset_classes="power-on,system-1-cvm,system-1-pin,system-2,application-1";
        field { sw=rw; reset=0x2008; } value[31:0];
    };
    pdma_word_t DMACTL @ 0xFFFF8000;
    DMACTL->desc="DMA global suspension; bit0=1 suspends without changing channel enables";
    DMACTL->writable_mask=1;
    pdma_status_t DMACER @ 0xFFFF8020;
    pdma_status_t DM0CMV @ 0xFFFF8030;
    pdma_status_t DM1CMV @ 0xFFFF8034;
    pdma_status_t DTSCMV @ 0xFFFF8038;
    pdma_word_t CMVC @ 0xFFFF803C;
    CMVC->writable_mask=7; CMVC->read_value=0;
    pdma_status_t TFRSTS @ 0xFFFF804C;
    pdma_master_t DM00CM @ 0xFFFF8100; pdma_master_t DM01CM @ 0xFFFF8104;
    pdma_master_t DM02CM @ 0xFFFF8108; pdma_master_t DM03CM @ 0xFFFF810C;
    pdma_master_t DM04CM @ 0xFFFF8110; pdma_master_t DM05CM @ 0xFFFF8114;
    pdma_master_t DM06CM @ 0xFFFF8118; pdma_master_t DM07CM @ 0xFFFF811C;
    pdma_master_t DM10CM @ 0xFFFF8120; pdma_master_t DM11CM @ 0xFFFF8124;
    pdma_master_t DM12CM @ 0xFFFF8128; pdma_master_t DM13CM @ 0xFFFF812C;
    pdma_master_t DM14CM @ 0xFFFF8130; pdma_master_t DM15CM @ 0xFFFF8134;
    pdma_master_t DM16CM @ 0xFFFF8138; pdma_master_t DM17CM @ 0xFFFF813C;
    pdma_word_t DMACTRGSEL0 @ 0xFFF99000;
    DMACTRGSEL0->writable_mask=0x7FF;
    DMACTRGSEL0->source_ref="R01UH0585EJ0120 Tables7.75,7.76";
    pdma_word_t DMACTRGSEL1 @ 0xFFF99004;
    DMACTRGSEL1->writable_mask=0x7FF;
    DMACTRGSEL1->source_ref="R01UH0585EJ0120 Tables7.75,7.76";

    reg pdma_control_t {
        regwidth=32; accesswidth=32; behavior="pdma"; writable_mask=0x0C1FFFFF;
        evidence="manual"; source_ref="R01UH0585EJ0120 Table7.50";
        reset_classes="power-on,system-1-cvm,system-1-pin,system-2,application-1";
        field { sw=rw; reset=0; } value[31:0];
    };
    reg pdma_compare_t {
        regwidth=32; accesswidth=32; behavior="pdma"; writable_mask=0xFFFF;
        evidence="manual"; source_ref="R01UH0585EJ0120 Table7.54";
        reset_classes="power-on,system-1-cvm,system-1-pin,system-2,application-1";
        field { sw=rw; reset=0; } value[31:0];
    };
    reg pdma_enable_t {
        regwidth=32; accesswidth=32; behavior="pdma"; writable_mask=1;
        evidence="manual"; source_ref="R01UH0585EJ0120 Table7.55";
        reset_classes="power-on,system-1-cvm,system-1-pin,system-2,application-1";
        field { sw=rw; reset=0; } value[31:0];
    };
    reg pdma_set_t {
        regwidth=32; accesswidth=32; behavior="pdma"; writable_mask=1; read_value=0;
        evidence="manual"; source_ref="R01UH0585EJ0120 Table7.57";
        reset_classes="power-on,system-1-cvm,system-1-pin,system-2,application-1";
        field { sw=rw; reset=0; } value[31:0];
    };
    reg pdma_clear_t {
        regwidth=32; accesswidth=32; behavior="pdma"; writable_mask=0xB1; read_value=0;
        evidence="manual"; source_ref="R01UH0585EJ0120 Table7.58";
        reset_classes="power-on,system-1-cvm,system-1-pin,system-2,application-1";
        field { sw=rw; reset=0; } value[31:0];
    };
    reg pdma_trigger_t {
        regwidth=32; accesswidth=32; behavior="pdma"; writable_mask=0xFF;
        evidence="manual"; source_ref="R01UH0585EJ0120 Table7.59";
        reset_classes="power-on,system-1-cvm,system-1-pin,system-2,application-1";
        field { sw=rw; reset=0; } value[31:0];
    };
    reg pdma_request_clear_t {
        regwidth=32; accesswidth=32; behavior="pdma"; writable_mask=3; read_value=0;
        evidence="manual"; source_ref="R01UH0585EJ0120 Table7.61; all P1M-E request sources are edge-type";
        reset_classes="power-on,system-1-cvm,system-1-pin,system-2,application-1";
        field { sw=rw; reset=0; } value[31:0];
    };
    pdma_word_t DSA0 @ 0xFFFF8400; pdma_word_t DDA0 @ 0xFFFF8404; pdma_word_t DTC0 @ 0xFFFF8408;
    pdma_control_t DTCT0 @ 0xFFFF840C;
    pdma_word_t DRSA0 @ 0xFFFF8410; pdma_word_t DRDA0 @ 0xFFFF8414; pdma_word_t DRTC0 @ 0xFFFF8418;
    pdma_compare_t DTCC0 @ 0xFFFF841C; pdma_enable_t DCEN0 @ 0xFFFF8420; pdma_status_t DCST0 @ 0xFFFF8424;
    pdma_set_t DCSTS0 @ 0xFFFF8428; pdma_clear_t DCSTC0 @ 0xFFFF842C;
    pdma_trigger_t DTFR0 @ 0xFFFF8430; pdma_status_t DTFRRQ0 @ 0xFFFF8434; pdma_request_clear_t DTFRRQC0 @ 0xFFFF8438;
    pdma_word_t DSA1 @ 0xFFFF8440; pdma_word_t DDA1 @ 0xFFFF8444; pdma_word_t DTC1 @ 0xFFFF8448;
    pdma_control_t DTCT1 @ 0xFFFF844C;
    pdma_word_t DRSA1 @ 0xFFFF8450; pdma_word_t DRDA1 @ 0xFFFF8454; pdma_word_t DRTC1 @ 0xFFFF8458;
    pdma_compare_t DTCC1 @ 0xFFFF845C; pdma_enable_t DCEN1 @ 0xFFFF8460; pdma_status_t DCST1 @ 0xFFFF8464;
    pdma_set_t DCSTS1 @ 0xFFFF8468; pdma_clear_t DCSTC1 @ 0xFFFF846C;
    pdma_trigger_t DTFR1 @ 0xFFFF8470; pdma_status_t DTFRRQ1 @ 0xFFFF8474; pdma_request_clear_t DTFRRQC1 @ 0xFFFF8478;
    pdma_word_t DSA2 @ 0xFFFF8480; pdma_word_t DDA2 @ 0xFFFF8484; pdma_word_t DTC2 @ 0xFFFF8488;
    pdma_control_t DTCT2 @ 0xFFFF848C;
    pdma_word_t DRSA2 @ 0xFFFF8490; pdma_word_t DRDA2 @ 0xFFFF8494; pdma_word_t DRTC2 @ 0xFFFF8498;
    pdma_compare_t DTCC2 @ 0xFFFF849C; pdma_enable_t DCEN2 @ 0xFFFF84A0; pdma_status_t DCST2 @ 0xFFFF84A4;
    pdma_set_t DCSTS2 @ 0xFFFF84A8; pdma_clear_t DCSTC2 @ 0xFFFF84AC;
    pdma_trigger_t DTFR2 @ 0xFFFF84B0; pdma_status_t DTFRRQ2 @ 0xFFFF84B4; pdma_request_clear_t DTFRRQC2 @ 0xFFFF84B8;
    pdma_word_t DSA3 @ 0xFFFF84C0; pdma_word_t DDA3 @ 0xFFFF84C4; pdma_word_t DTC3 @ 0xFFFF84C8;
    pdma_control_t DTCT3 @ 0xFFFF84CC;
    pdma_word_t DRSA3 @ 0xFFFF84D0; pdma_word_t DRDA3 @ 0xFFFF84D4; pdma_word_t DRTC3 @ 0xFFFF84D8;
    pdma_compare_t DTCC3 @ 0xFFFF84DC; pdma_enable_t DCEN3 @ 0xFFFF84E0; pdma_status_t DCST3 @ 0xFFFF84E4;
    pdma_set_t DCSTS3 @ 0xFFFF84E8; pdma_clear_t DCSTC3 @ 0xFFFF84EC;
    pdma_trigger_t DTFR3 @ 0xFFFF84F0; pdma_status_t DTFRRQ3 @ 0xFFFF84F4; pdma_request_clear_t DTFRRQC3 @ 0xFFFF84F8;
    pdma_word_t DSA4 @ 0xFFFF8500; pdma_word_t DDA4 @ 0xFFFF8504; pdma_word_t DTC4 @ 0xFFFF8508;
    pdma_control_t DTCT4 @ 0xFFFF850C;
    pdma_word_t DRSA4 @ 0xFFFF8510; pdma_word_t DRDA4 @ 0xFFFF8514; pdma_word_t DRTC4 @ 0xFFFF8518;
    pdma_compare_t DTCC4 @ 0xFFFF851C; pdma_enable_t DCEN4 @ 0xFFFF8520; pdma_status_t DCST4 @ 0xFFFF8524;
    pdma_set_t DCSTS4 @ 0xFFFF8528; pdma_clear_t DCSTC4 @ 0xFFFF852C;
    pdma_trigger_t DTFR4 @ 0xFFFF8530; pdma_status_t DTFRRQ4 @ 0xFFFF8534; pdma_request_clear_t DTFRRQC4 @ 0xFFFF8538;
    pdma_word_t DSA5 @ 0xFFFF8540; pdma_word_t DDA5 @ 0xFFFF8544; pdma_word_t DTC5 @ 0xFFFF8548;
    pdma_control_t DTCT5 @ 0xFFFF854C;
    pdma_word_t DRSA5 @ 0xFFFF8550; pdma_word_t DRDA5 @ 0xFFFF8554; pdma_word_t DRTC5 @ 0xFFFF8558;
    pdma_compare_t DTCC5 @ 0xFFFF855C; pdma_enable_t DCEN5 @ 0xFFFF8560; pdma_status_t DCST5 @ 0xFFFF8564;
    pdma_set_t DCSTS5 @ 0xFFFF8568; pdma_clear_t DCSTC5 @ 0xFFFF856C;
    pdma_trigger_t DTFR5 @ 0xFFFF8570; pdma_status_t DTFRRQ5 @ 0xFFFF8574; pdma_request_clear_t DTFRRQC5 @ 0xFFFF8578;
    pdma_word_t DSA6 @ 0xFFFF8580; pdma_word_t DDA6 @ 0xFFFF8584; pdma_word_t DTC6 @ 0xFFFF8588;
    pdma_control_t DTCT6 @ 0xFFFF858C;
    pdma_word_t DRSA6 @ 0xFFFF8590; pdma_word_t DRDA6 @ 0xFFFF8594; pdma_word_t DRTC6 @ 0xFFFF8598;
    pdma_compare_t DTCC6 @ 0xFFFF859C; pdma_enable_t DCEN6 @ 0xFFFF85A0; pdma_status_t DCST6 @ 0xFFFF85A4;
    pdma_set_t DCSTS6 @ 0xFFFF85A8; pdma_clear_t DCSTC6 @ 0xFFFF85AC;
    pdma_trigger_t DTFR6 @ 0xFFFF85B0; pdma_status_t DTFRRQ6 @ 0xFFFF85B4; pdma_request_clear_t DTFRRQC6 @ 0xFFFF85B8;
    pdma_word_t DSA7 @ 0xFFFF85C0; pdma_word_t DDA7 @ 0xFFFF85C4; pdma_word_t DTC7 @ 0xFFFF85C8;
    pdma_control_t DTCT7 @ 0xFFFF85CC;
    pdma_word_t DRSA7 @ 0xFFFF85D0; pdma_word_t DRDA7 @ 0xFFFF85D4; pdma_word_t DRTC7 @ 0xFFFF85D8;
    pdma_compare_t DTCC7 @ 0xFFFF85DC; pdma_enable_t DCEN7 @ 0xFFFF85E0; pdma_status_t DCST7 @ 0xFFFF85E4;
    pdma_set_t DCSTS7 @ 0xFFFF85E8; pdma_clear_t DCSTC7 @ 0xFFFF85EC;
    pdma_trigger_t DTFR7 @ 0xFFFF85F0; pdma_status_t DTFRRQ7 @ 0xFFFF85F4; pdma_request_clear_t DTFRRQC7 @ 0xFFFF85F8;
    pdma_word_t DSA8 @ 0xFFFF8600; pdma_word_t DDA8 @ 0xFFFF8604; pdma_word_t DTC8 @ 0xFFFF8608;
    pdma_control_t DTCT8 @ 0xFFFF860C;
    pdma_word_t DRSA8 @ 0xFFFF8610; pdma_word_t DRDA8 @ 0xFFFF8614; pdma_word_t DRTC8 @ 0xFFFF8618;
    pdma_compare_t DTCC8 @ 0xFFFF861C; pdma_enable_t DCEN8 @ 0xFFFF8620; pdma_status_t DCST8 @ 0xFFFF8624;
    pdma_set_t DCSTS8 @ 0xFFFF8628; pdma_clear_t DCSTC8 @ 0xFFFF862C;
    pdma_trigger_t DTFR8 @ 0xFFFF8630; pdma_status_t DTFRRQ8 @ 0xFFFF8634; pdma_request_clear_t DTFRRQC8 @ 0xFFFF8638;
    pdma_word_t DSA9 @ 0xFFFF8640; pdma_word_t DDA9 @ 0xFFFF8644; pdma_word_t DTC9 @ 0xFFFF8648;
    pdma_control_t DTCT9 @ 0xFFFF864C;
    pdma_word_t DRSA9 @ 0xFFFF8650; pdma_word_t DRDA9 @ 0xFFFF8654; pdma_word_t DRTC9 @ 0xFFFF8658;
    pdma_compare_t DTCC9 @ 0xFFFF865C; pdma_enable_t DCEN9 @ 0xFFFF8660; pdma_status_t DCST9 @ 0xFFFF8664;
    pdma_set_t DCSTS9 @ 0xFFFF8668; pdma_clear_t DCSTC9 @ 0xFFFF866C;
    pdma_trigger_t DTFR9 @ 0xFFFF8670; pdma_status_t DTFRRQ9 @ 0xFFFF8674; pdma_request_clear_t DTFRRQC9 @ 0xFFFF8678;
    pdma_word_t DSA10 @ 0xFFFF8680; pdma_word_t DDA10 @ 0xFFFF8684; pdma_word_t DTC10 @ 0xFFFF8688;
    pdma_control_t DTCT10 @ 0xFFFF868C;
    pdma_word_t DRSA10 @ 0xFFFF8690; pdma_word_t DRDA10 @ 0xFFFF8694; pdma_word_t DRTC10 @ 0xFFFF8698;
    pdma_compare_t DTCC10 @ 0xFFFF869C; pdma_enable_t DCEN10 @ 0xFFFF86A0; pdma_status_t DCST10 @ 0xFFFF86A4;
    pdma_set_t DCSTS10 @ 0xFFFF86A8; pdma_clear_t DCSTC10 @ 0xFFFF86AC;
    pdma_trigger_t DTFR10 @ 0xFFFF86B0; pdma_status_t DTFRRQ10 @ 0xFFFF86B4; pdma_request_clear_t DTFRRQC10 @ 0xFFFF86B8;
    pdma_word_t DSA11 @ 0xFFFF86C0; pdma_word_t DDA11 @ 0xFFFF86C4; pdma_word_t DTC11 @ 0xFFFF86C8;
    pdma_control_t DTCT11 @ 0xFFFF86CC;
    pdma_word_t DRSA11 @ 0xFFFF86D0; pdma_word_t DRDA11 @ 0xFFFF86D4; pdma_word_t DRTC11 @ 0xFFFF86D8;
    pdma_compare_t DTCC11 @ 0xFFFF86DC; pdma_enable_t DCEN11 @ 0xFFFF86E0; pdma_status_t DCST11 @ 0xFFFF86E4;
    pdma_set_t DCSTS11 @ 0xFFFF86E8; pdma_clear_t DCSTC11 @ 0xFFFF86EC;
    pdma_trigger_t DTFR11 @ 0xFFFF86F0; pdma_status_t DTFRRQ11 @ 0xFFFF86F4; pdma_request_clear_t DTFRRQC11 @ 0xFFFF86F8;
    pdma_word_t DSA12 @ 0xFFFF8700; pdma_word_t DDA12 @ 0xFFFF8704; pdma_word_t DTC12 @ 0xFFFF8708;
    pdma_control_t DTCT12 @ 0xFFFF870C;
    pdma_word_t DRSA12 @ 0xFFFF8710; pdma_word_t DRDA12 @ 0xFFFF8714; pdma_word_t DRTC12 @ 0xFFFF8718;
    pdma_compare_t DTCC12 @ 0xFFFF871C; pdma_enable_t DCEN12 @ 0xFFFF8720; pdma_status_t DCST12 @ 0xFFFF8724;
    pdma_set_t DCSTS12 @ 0xFFFF8728; pdma_clear_t DCSTC12 @ 0xFFFF872C;
    pdma_trigger_t DTFR12 @ 0xFFFF8730; pdma_status_t DTFRRQ12 @ 0xFFFF8734; pdma_request_clear_t DTFRRQC12 @ 0xFFFF8738;
    pdma_word_t DSA13 @ 0xFFFF8740; pdma_word_t DDA13 @ 0xFFFF8744; pdma_word_t DTC13 @ 0xFFFF8748;
    pdma_control_t DTCT13 @ 0xFFFF874C;
    pdma_word_t DRSA13 @ 0xFFFF8750; pdma_word_t DRDA13 @ 0xFFFF8754; pdma_word_t DRTC13 @ 0xFFFF8758;
    pdma_compare_t DTCC13 @ 0xFFFF875C; pdma_enable_t DCEN13 @ 0xFFFF8760; pdma_status_t DCST13 @ 0xFFFF8764;
    pdma_set_t DCSTS13 @ 0xFFFF8768; pdma_clear_t DCSTC13 @ 0xFFFF876C;
    pdma_trigger_t DTFR13 @ 0xFFFF8770; pdma_status_t DTFRRQ13 @ 0xFFFF8774; pdma_request_clear_t DTFRRQC13 @ 0xFFFF8778;
    pdma_word_t DSA14 @ 0xFFFF8780; pdma_word_t DDA14 @ 0xFFFF8784; pdma_word_t DTC14 @ 0xFFFF8788;
    pdma_control_t DTCT14 @ 0xFFFF878C;
    pdma_word_t DRSA14 @ 0xFFFF8790; pdma_word_t DRDA14 @ 0xFFFF8794; pdma_word_t DRTC14 @ 0xFFFF8798;
    pdma_compare_t DTCC14 @ 0xFFFF879C; pdma_enable_t DCEN14 @ 0xFFFF87A0; pdma_status_t DCST14 @ 0xFFFF87A4;
    pdma_set_t DCSTS14 @ 0xFFFF87A8; pdma_clear_t DCSTC14 @ 0xFFFF87AC;
    pdma_trigger_t DTFR14 @ 0xFFFF87B0; pdma_status_t DTFRRQ14 @ 0xFFFF87B4; pdma_request_clear_t DTFRRQC14 @ 0xFFFF87B8;
    pdma_word_t DSA15 @ 0xFFFF87C0; pdma_word_t DDA15 @ 0xFFFF87C4; pdma_word_t DTC15 @ 0xFFFF87C8;
    pdma_control_t DTCT15 @ 0xFFFF87CC;
    pdma_word_t DRSA15 @ 0xFFFF87D0; pdma_word_t DRDA15 @ 0xFFFF87D4; pdma_word_t DRTC15 @ 0xFFFF87D8;
    pdma_compare_t DTCC15 @ 0xFFFF87DC; pdma_enable_t DCEN15 @ 0xFFFF87E0; pdma_status_t DCST15 @ 0xFFFF87E4;
    pdma_set_t DCSTS15 @ 0xFFFF87E8; pdma_clear_t DCSTC15 @ 0xFFFF87EC;
    pdma_trigger_t DTFR15 @ 0xFFFF87F0; pdma_status_t DTFRRQ15 @ 0xFFFF87F4; pdma_request_clear_t DTFRRQC15 @ 0xFFFF87F8;

    // Section14 functional controller surface; TX/RX data has no reset payload.
    reg csih_ctl0_t {
        regwidth=8; accesswidth=8; behavior="csih"; trigger="ctl0"; writable_mask=0xE3;
        evidence="manual"; source_ref="R01UH0585EJ0120 Tables14.5,14.7,14.13";
        reset_classes="power-on,system-1-cvm,system-1-pin,system-2,application-1";
        field { sw=rw; reset=0; } value[7:0];
    };
    reg csih_word_t {
        regwidth=32; accesswidth=32; behavior="csih";
        evidence="manual"; source_ref="R01UH0585EJ0120 section14.3 Tables14.14,14.24-14.30";
        reset_classes="power-on,system-1-cvm,system-1-pin,system-2,application-1";
        field { sw=rw; reset=0; } value[31:0];
    };
    reg csih_half_t {
        regwidth=16; accesswidth=16; behavior="csih";
        evidence="manual"; source_ref="R01UH0585EJ0120 section14.3 Tables14.17,14.22,14.23,14.29,14.31,14.32";
        reset_classes="power-on,system-1-cvm,system-1-pin,system-2,application-1";
        field { sw=rw; reset=0; } value[15:0];
    };
    reg csih_data_word_t {
        regwidth=32; accesswidth=32; behavior="csih";
        evidence="manual"; source_ref="R01UH0585EJ0120 Tables14.28,14.30; payload undefined after reset";
        reset_classes="power-on,system-1-cvm,system-1-pin,system-2,application-1";
        field { sw=rw; } value[31:0];
    };
    reg csih_data_half_t {
        regwidth=16; accesswidth=16; behavior="csih";
        evidence="manual"; source_ref="R01UH0585EJ0120 Tables14.29,14.31; payload undefined after reset";
        reset_classes="power-on,system-1-cvm,system-1-pin,system-2,application-1";
        field { sw=rw; } value[15:0];
    };
    csih_ctl0_t CSIH0CTL0 @ 0xFFD80000;
    csih_ctl0_t CSIH1CTL0 @ 0xFFD82000;
    csih_ctl0_t CSIH2CTL0 @ 0xFFD84000;
    csih_ctl0_t CSIH3CTL0 @ 0xFFD86000;
    CSIH0CTL0->control_register="CSIH0CTL0"; CSIH0CTL0->interrupt_channel_base=82;
    CSIH1CTL0->control_register="CSIH1CTL0"; CSIH1CTL0->interrupt_channel_base=90;
    CSIH2CTL0->control_register="CSIH2CTL0"; CSIH2CTL0->interrupt_channel_base=98;
    CSIH3CTL0->control_register="CSIH3CTL0"; CSIH3CTL0->interrupt_channel_base=102;
    csih_word_t CSIH0STR0 @ 0xFFD80004; CSIH0STR0.value->sw=r; CSIH0STR0.value->reset=0x10;
    csih_word_t CSIH1STR0 @ 0xFFD82004; CSIH1STR0.value->sw=r; CSIH1STR0.value->reset=0x10;
    csih_word_t CSIH2STR0 @ 0xFFD84004; CSIH2STR0.value->sw=r; CSIH2STR0.value->reset=0x10;
    csih_word_t CSIH3STR0 @ 0xFFD86004; CSIH3STR0.value->sw=r; CSIH3STR0.value->reset=0x10;
    csih_half_t CSIH0STCR0 @ 0xFFD80008;
    csih_half_t CSIH1STCR0 @ 0xFFD82008;
    csih_half_t CSIH2STCR0 @ 0xFFD84008;
    csih_half_t CSIH3STCR0 @ 0xFFD86008;
    CSIH0STCR0->trigger="stcr0"; CSIH0STCR0->writable_mask=0xC10B; CSIH0STCR0->read_value=0;
    CSIH1STCR0->trigger="stcr0"; CSIH1STCR0->writable_mask=0xC10B; CSIH1STCR0->read_value=0;
    CSIH2STCR0->trigger="stcr0"; CSIH2STCR0->writable_mask=0xC10B; CSIH2STCR0->read_value=0;
    CSIH3STCR0->trigger="stcr0"; CSIH3STCR0->writable_mask=0xC10B; CSIH3STCR0->read_value=0;
    csih_word_t CSIH0CTL1 @ 0xFFD80010; CSIH0CTL1->writable_mask=0x7FFFF;
    csih_word_t CSIH1CTL1 @ 0xFFD82010; CSIH1CTL1->writable_mask=0x7FFFF;
    csih_word_t CSIH2CTL1 @ 0xFFD84010; CSIH2CTL1->writable_mask=0x7FFFF;
    csih_word_t CSIH3CTL1 @ 0xFFD86010; CSIH3CTL1->writable_mask=0x7FFFF;
    csih_half_t CSIH0CTL2 @ 0xFFD80014; CSIH0CTL2->writable_mask=0xE000; CSIH0CTL2.value->reset=0xE000;
    csih_half_t CSIH1CTL2 @ 0xFFD82014; CSIH1CTL2->writable_mask=0xE000; CSIH1CTL2.value->reset=0xE000;
    csih_half_t CSIH2CTL2 @ 0xFFD84014; CSIH2CTL2->writable_mask=0xE000; CSIH2CTL2.value->reset=0xE000;
    csih_half_t CSIH3CTL2 @ 0xFFD86014; CSIH3CTL2->writable_mask=0xE000; CSIH3CTL2.value->reset=0xE000;
    csih_word_t CSIH0MCTL1 @ 0xFFD81000; CSIH0MCTL1->writable_mask=0x7F007F;
    csih_word_t CSIH1MCTL1 @ 0xFFD83000; CSIH1MCTL1->writable_mask=0x7F007F;
    csih_word_t CSIH2MCTL1 @ 0xFFD85000; CSIH2MCTL1->writable_mask=0x7F007F;
    csih_word_t CSIH3MCTL1 @ 0xFFD87000; CSIH3MCTL1->writable_mask=0x7F007F;
    csih_word_t CSIH0MCTL2 @ 0xFFD81004; CSIH0MCTL2->trigger="mctl2"; CSIH0MCTL2->writable_mask=0x80FF007F;
    csih_word_t CSIH1MCTL2 @ 0xFFD83004; CSIH1MCTL2->trigger="mctl2"; CSIH1MCTL2->writable_mask=0x80FF007F;
    csih_word_t CSIH2MCTL2 @ 0xFFD85004; CSIH2MCTL2->trigger="mctl2"; CSIH2MCTL2->writable_mask=0x80FF007F;
    csih_word_t CSIH3MCTL2 @ 0xFFD87004; CSIH3MCTL2->trigger="mctl2"; CSIH3MCTL2->writable_mask=0x80FF007F;
    csih_data_word_t CSIH0TX0W @ 0xFFD81008; CSIH0TX0W->trigger="tx"; CSIH0TX0W->writable_mask=0xE0FFFFFF;
    csih_data_word_t CSIH1TX0W @ 0xFFD83008; CSIH1TX0W->trigger="tx"; CSIH1TX0W->writable_mask=0xE0FFFFFF;
    csih_data_word_t CSIH2TX0W @ 0xFFD85008; CSIH2TX0W->trigger="tx"; CSIH2TX0W->writable_mask=0xE0FFFFFF;
    csih_data_word_t CSIH3TX0W @ 0xFFD87008; CSIH3TX0W->trigger="tx"; CSIH3TX0W->writable_mask=0xE0FFFFFF;
    csih_data_half_t CSIH0TX0H @ 0xFFD8100C; CSIH0TX0H->trigger="tx-half"; CSIH0TX0H->writable_mask=0xFFFF;
    csih_data_half_t CSIH1TX0H @ 0xFFD8300C; CSIH1TX0H->trigger="tx-half"; CSIH1TX0H->writable_mask=0xFFFF;
    csih_data_half_t CSIH2TX0H @ 0xFFD8500C; CSIH2TX0H->trigger="tx-half"; CSIH2TX0H->writable_mask=0xFFFF;
    csih_data_half_t CSIH3TX0H @ 0xFFD8700C; CSIH3TX0H->trigger="tx-half"; CSIH3TX0H->writable_mask=0xFFFF;
    csih_data_word_t CSIH0RX0W @ 0xFFD81010; CSIH0RX0W->trigger="rx"; CSIH0RX0W.value->sw=r;
    csih_data_word_t CSIH1RX0W @ 0xFFD83010; CSIH1RX0W->trigger="rx"; CSIH1RX0W.value->sw=r;
    csih_data_word_t CSIH2RX0W @ 0xFFD85010; CSIH2RX0W->trigger="rx"; CSIH2RX0W.value->sw=r;
    csih_data_word_t CSIH3RX0W @ 0xFFD87010; CSIH3RX0W->trigger="rx"; CSIH3RX0W.value->sw=r;
    csih_data_half_t CSIH0RX0H @ 0xFFD81014; CSIH0RX0H->trigger="rx"; CSIH0RX0H.value->sw=r;
    csih_data_half_t CSIH1RX0H @ 0xFFD83014; CSIH1RX0H->trigger="rx"; CSIH1RX0H.value->sw=r;
    csih_data_half_t CSIH2RX0H @ 0xFFD85014; CSIH2RX0H->trigger="rx"; CSIH2RX0H.value->sw=r;
    csih_data_half_t CSIH3RX0H @ 0xFFD87014; CSIH3RX0H->trigger="rx"; CSIH3RX0H.value->sw=r;
    csih_word_t CSIH0MRWP0 @ 0xFFD81018; CSIH0MRWP0->writable_mask=0x7F007F;
    csih_word_t CSIH1MRWP0 @ 0xFFD83018; CSIH1MRWP0->writable_mask=0x7F007F;
    csih_word_t CSIH2MRWP0 @ 0xFFD85018; CSIH2MRWP0->writable_mask=0x7F007F;
    csih_word_t CSIH3MRWP0 @ 0xFFD87018; CSIH3MRWP0->writable_mask=0x7F007F;
    csih_half_t CSIH0MCTL0 @ 0xFFD81040; CSIH0MCTL0->writable_mask=0x31F;
    csih_half_t CSIH1MCTL0 @ 0xFFD83040; CSIH1MCTL0->writable_mask=0x31F;
    csih_half_t CSIH2MCTL0 @ 0xFFD85040; CSIH2MCTL0->writable_mask=0x31F;
    csih_half_t CSIH3MCTL0 @ 0xFFD87040; CSIH3MCTL0->writable_mask=0x31F;
    csih_word_t CSIH0CFG0 @ 0xFFD81044; csih_word_t CSIH0CFG1 @ 0xFFD81048;
    csih_word_t CSIH0CFG2 @ 0xFFD8104C; csih_word_t CSIH0CFG3 @ 0xFFD81050;
    csih_word_t CSIH0CFG4 @ 0xFFD81054; csih_word_t CSIH0CFG5 @ 0xFFD81058;
    csih_word_t CSIH0CFG6 @ 0xFFD8105C; csih_word_t CSIH0CFG7 @ 0xFFD81060;
    csih_word_t CSIH1CFG0 @ 0xFFD83044; csih_word_t CSIH1CFG1 @ 0xFFD83048;
    csih_word_t CSIH1CFG2 @ 0xFFD8304C; csih_word_t CSIH1CFG3 @ 0xFFD83050;
    csih_word_t CSIH1CFG4 @ 0xFFD83054; csih_word_t CSIH1CFG5 @ 0xFFD83058;
    csih_word_t CSIH1CFG6 @ 0xFFD8305C; csih_word_t CSIH1CFG7 @ 0xFFD83060;
    csih_word_t CSIH2CFG0 @ 0xFFD85044; csih_word_t CSIH2CFG1 @ 0xFFD85048;
    csih_word_t CSIH2CFG2 @ 0xFFD8504C; csih_word_t CSIH2CFG3 @ 0xFFD85050;
    csih_word_t CSIH2CFG4 @ 0xFFD85054; csih_word_t CSIH2CFG5 @ 0xFFD85058;
    csih_word_t CSIH2CFG6 @ 0xFFD8505C; csih_word_t CSIH2CFG7 @ 0xFFD85060;
    csih_word_t CSIH3CFG0 @ 0xFFD87044; csih_word_t CSIH3CFG1 @ 0xFFD87048;
    csih_word_t CSIH3CFG2 @ 0xFFD8704C; csih_word_t CSIH3CFG3 @ 0xFFD87050;
    csih_word_t CSIH3CFG4 @ 0xFFD87054; csih_word_t CSIH3CFG5 @ 0xFFD87058;
    csih_word_t CSIH3CFG6 @ 0xFFD8705C; csih_word_t CSIH3CFG7 @ 0xFFD87060;
    csih_half_t CSIH0BRS0 @ 0xFFD81068; csih_half_t CSIH0BRS1 @ 0xFFD8106C;
    csih_half_t CSIH0BRS2 @ 0xFFD81070; csih_half_t CSIH0BRS3 @ 0xFFD81074;
    csih_half_t CSIH1BRS0 @ 0xFFD83068; csih_half_t CSIH1BRS1 @ 0xFFD8306C;
    csih_half_t CSIH1BRS2 @ 0xFFD83070; csih_half_t CSIH1BRS3 @ 0xFFD83074;
    csih_half_t CSIH2BRS0 @ 0xFFD85068; csih_half_t CSIH2BRS1 @ 0xFFD8506C;
    csih_half_t CSIH2BRS2 @ 0xFFD85070; csih_half_t CSIH2BRS3 @ 0xFFD85074;
    csih_half_t CSIH3BRS0 @ 0xFFD87068; csih_half_t CSIH3BRS1 @ 0xFFD8706C;
    csih_half_t CSIH3BRS2 @ 0xFFD87070; csih_half_t CSIH3BRS3 @ 0xFFD87074;
    csih_ctl0_t SELCSIHDMA @ 0xFFD8E000;
    SELCSIHDMA->trigger="dma-select"; SELCSIHDMA->writable_mask=0xF;
    SELCSIHDMA->desc="CSIH0/1 CS0 interrupt and DMA trigger gating";
    SELCSIHDMA->source_ref="R01UH0585EJ0120 section14.3.17 Table14.33";

    peripheral_ecc_control ECCCSIH0CTL @ 0xFFC70000;
    peripheral_ecc_test ECCCSIH0TMC @ 0xFFC70004;
    peripheral_ecc_control ECCCSIH1CTL @ 0xFFC70040;
    peripheral_ecc_test ECCCSIH1TMC @ 0xFFC70044;
    peripheral_ecc_control ECCCSIH2CTL @ 0xFFC70080;
    peripheral_ecc_test ECCCSIH2TMC @ 0xFFC70084;
    peripheral_ecc_control ECCCSIH3CTL @ 0xFFC700C0;
    peripheral_ecc_test ECCCSIH3TMC @ 0xFFC700C4;
    peripheral_ecc_control ECCCAN0CTL @ 0xFFC71100;
    peripheral_ecc_test ECCCAN0TMC @ 0xFFC71104;
    peripheral_ecc_control ECCCAN1CTL @ 0xFFC71200;
    peripheral_ecc_test ECCCAN1TMC @ 0xFFC71204;

    reg backup_register_t {
        regwidth=32; accesswidth=32; behavior="storage";
        desc="Backup data retained across every reset and BIST; initial contents unspecified";
        evidence="manual"; source_ref="R01UH0585EJ0120 section36.3.2 Table36.2";
        field { sw=rw; } value[31:0];
    };
    backup_register_t BRAMDAT0 @ 0xFFC0A000;
    backup_register_t BRAMDAT1 @ 0xFFC0A004;
    backup_register_t BRAMDAT2 @ 0xFFC0A008;
    backup_register_t BRAMDAT3 @ 0xFFC0A00C;


    // Guard configuration is not a key sequence: the apparent key constants
    // contain reserved reset bits. LOCK is sticky until every listed reset.
    reg peg_mask_t {
        regwidth=32; accesswidth=8; access_widths="1,2,4"; behavior="peg";
        trigger="peg-mask"; writable_mask=0xFFFFF000;
        desc="PE guard address mask; a write clears the corresponding BA.EN";
        evidence="manual"; source_ref="R01UH0585EJ0120 Tables3.60,3.62-3.64 section31.4.1(3)";
        reset_classes="power-on,system-1-cvm,system-1-pin,system-2,application-1";
        field { sw=rw; reset=0; } value[31:0];
    };
    reg peg_base_t {
        regwidth=32; accesswidth=8; access_widths="1,2,4"; behavior="peg";
        trigger="peg-base"; writable_mask=0xFFFFF017;
        desc="PE guard base, LOCK, write/read permission and enable";
        evidence="manual"; source_ref="R01UH0585EJ0120 Tables3.60,3.63 section31.4.1(3)";
        reset_classes="power-on,system-1-cvm,system-1-pin,system-2,application-1";
        field { sw=rw; reset=0; } value[31:0];
    };
    reg guard_spid_t {
        regwidth=32; accesswidth=32; behavior="bus-guard";
        trigger="guard-spid"; writable_mask=0xFFFFFFFF;
        desc="Allowed bus-master SPID bitmap, protected by corresponding LOCK";
        evidence="manual"; source_ref="R01UH0585EJ0120 Tables31.151,31.163,31.168,31.175";
        reset_classes="power-on,system-1-cvm,system-1-pin,system-2,application-1";
        field { sw=rw; reset=0xFFFFFFFF; } value[31:0];
    };
    reg peg_spid_t {
        regwidth=32; accesswidth=8; access_widths="1,2,4"; behavior="peg";
        trigger="peg-spid"; writable_mask=0xFFFFFFFF;
        desc="PE guard allowed external-master SPID bitmap; own PE is not checked";
        evidence="manual"; source_ref="R01UH0585EJ0120 Tables3.60,3.64 section31.4.1(3)";
        reset_classes="power-on,system-1-cvm,system-1-pin,system-2,application-1";
        field { sw=rw; reset=0; } value[31:0];
    };
    peg_mask_t PEGG0MK @ 0xFFFEE680; PEGG0MK.value->reset=0x003FF000;
    peg_base_t PEGG0BA @ 0xFFFEE684; PEGG0BA.value->reset=0xFE800003;
    peg_spid_t PEGG0SP @ 0xFFFEE688; PEGG0SP.value->reset=3;
    peg_mask_t PEGG1MK @ 0xFFFEE690;
    peg_base_t PEGG1BA @ 0xFFFEE694;
    peg_spid_t PEGG1SP @ 0xFFFEE698;
    peg_mask_t PEGG2MK @ 0xFFFEE6A0;
    peg_base_t PEGG2BA @ 0xFFFEE6A4;
    peg_spid_t PEGG2SP @ 0xFFFEE6A8;
    peg_mask_t PEGG3MK @ 0xFFFEE6B0;
    peg_base_t PEGG3BA @ 0xFFFEE6B4;
    peg_spid_t PEGG3SP @ 0xFFFEE6B8;
    peg_mask_t PEGG4MK @ 0xFFFEE6C0;
    peg_base_t PEGG4BA @ 0xFFFEE6C4;
    peg_spid_t PEGG4SP @ 0xFFFEE6C8;
    peg_mask_t PEGG5MK @ 0xFFFEE6D0;
    peg_base_t PEGG5BA @ 0xFFFEE6D4;
    peg_spid_t PEGG5SP @ 0xFFFEE6D8;
    peg_mask_t PEGG6MK @ 0xFFFEE6E0;
    peg_base_t PEGG6BA @ 0xFFFEE6E4;
    peg_spid_t PEGG6SP @ 0xFFFEE6E8;
    peg_mask_t PEGG7MK @ 0xFFFEE6F0;
    peg_base_t PEGG7BA @ 0xFFFEE6F4;
    peg_spid_t PEGG7SP @ 0xFFFEE6F8;

    // Guard violation capture is separate from the protected configuration.
    reg guard_error_status_t {
        regwidth=32; accesswidth=32; behavior="guard-error";
        evidence="manual"; source_ref="R01UH0585EJ0120 Tables31.155,31.164,31.170";
        reset_classes="power-on,system-1-cvm,system-1-pin,system-2,application-1";
        field { sw=r; reset=0; } value[31:0];
    };
    reg guard_error_clear_t {
        regwidth=32; accesswidth=32; behavior="guard-error"; trigger="guard-error-clear";
        writable_mask=3; evidence="manual"; source_ref="R01UH0585EJ0120 Tables31.154,31.163";
        reset_classes="power-on,system-1-cvm,system-1-pin,system-2,application-1";
        field { sw=w; reset=0; } value[31:0];
    };
    reg guard_error_clear_byte_t {
        regwidth=8; accesswidth=8; behavior="guard-error"; trigger="guard-error-clear";
        writable_mask=3; evidence="manual"; source_ref="R01UH0585EJ0120 Table31.169";
        reset_classes="power-on,system-1-cvm,system-1-pin,system-2,application-1";
        field { sw=w; reset=0; } value[7:0];
    };
    reg gram_error_type_t {
        regwidth=32; accesswidth=8; access_widths="1,2,4"; behavior="guard-error";
        evidence="manual"; source_ref="R01UH0585EJ0120 Table31.156; undefined until capture";
        reset_classes="power-on,system-1-cvm,system-1-pin,system-2,application-1";
        field { sw=r; } value[31:0];
    };
    guard_error_clear_t PGERRSTATCTL_PE1 @ 0xFFC4A200;
    PGERRSTATCTL_PE1.value->sw=rw; PGERRSTATCTL_PE1->accesswidth=8; PGERRSTATCTL_PE1->access_widths="1,2,4";
    PGERRSTATCTL_PE1->source_ref="R01UH0585EJ0120 Table3.65";
    PGERRSTATCTL_PE1->status_register="PGERRSTAT_PE1"; PGERRSTATCTL_PE1->read_value=0;
    guard_error_status_t PGERRSTAT_PE1 @ 0xFFC4A204;
    PGERRSTAT_PE1->accesswidth=8; PGERRSTAT_PE1->access_widths="1,2,4";
    PGERRSTAT_PE1->source_ref="R01UH0585EJ0120 Table3.66";
    guard_error_status_t PGERRINFO_PE1 @ 0xFFC4A208;
    PGERRINFO_PE1->accesswidth=8; PGERRINFO_PE1->access_widths="1,2,4";
    PGERRINFO_PE1->source_ref="R01UH0585EJ0120 Table3.67";
    guard_error_clear_t MGDGRSCTL_VCI2GRAM @ 0xFFC49100;
    MGDGRSCTL_VCI2GRAM.value->sw=rw; MGDGRSCTL_VCI2GRAM->read_value=0;
    MGDGRSCTL_VCI2GRAM->status_register="MGDGRSSTAT_VCI2GRAM";
    guard_error_status_t MGDGRSSTAT_VCI2GRAM @ 0xFFC49104;
    gram_error_type_t MGDGRSTYPE_VCI2GRAM @ 0xFFC4910C;
    guard_error_clear_t MGDGRSCTL_PE1 @ 0xFFC49200;
    MGDGRSCTL_PE1.value->sw=rw; MGDGRSCTL_PE1->read_value=0;
    MGDGRSCTL_PE1->status_register="MGDGRSSTAT_PE1";
    guard_error_status_t MGDGRSSTAT_PE1 @ 0xFFC49204;
    gram_error_type_t MGDGRSTYPE_PE1 @ 0xFFC4920C;
    guard_error_clear_t MGDGRSCTL_AXI2GRAM @ 0xFFC49700;
    MGDGRSCTL_AXI2GRAM.value->sw=rw; MGDGRSCTL_AXI2GRAM->read_value=0;
    MGDGRSCTL_AXI2GRAM->status_register="MGDGRSSTAT_AXI2GRAM";
    guard_error_status_t MGDGRSSTAT_AXI2GRAM @ 0xFFC49704;
    gram_error_type_t MGDGRSTYPE_AXI2GRAM @ 0xFFC4970C;
    guard_error_clear_t ERRSLVCTL_PFSS0 @ 0xFFC4C800;
    ERRSLVCTL_PFSS0->status_register="ERRSLVSTAT_PFSS0";
    guard_error_status_t ERRSLVSTAT_PFSS0 @ 0xFFC4C804;
    guard_error_status_t ERRSLVTYPE_PFSS0 @ 0xFFC4C80C;
    ERRSLVTYPE_PFSS0->source_ref="R01UH0585EJ0120 Table31.165";
    guard_error_clear_t ERRSLVCTL_PFSS1 @ 0xFFC4C810;
    ERRSLVCTL_PFSS1->status_register="ERRSLVSTAT_PFSS1";
    guard_error_status_t ERRSLVSTAT_PFSS1 @ 0xFFC4C814;
    guard_error_status_t ERRSLVTYPE_PFSS1 @ 0xFFC4C81C;
    ERRSLVTYPE_PFSS1->source_ref="R01UH0585EJ0120 Table31.165";
    guard_error_clear_byte_t ERRSLV0CTL @ 0xFFC5A100;
    ERRSLV0CTL->status_register="ERRSLV0STAT";
    guard_error_status_t ERRSLV0STAT @ 0xFFC5A104;
    guard_error_status_t ERRSLV0TYPE @ 0xFFC5A10C;
    ERRSLV0TYPE->source_ref="R01UH0585EJ0120 Table31.171";
    guard_error_clear_byte_t ERRSLV1CTL @ 0xFFDDD400;
    ERRSLV1CTL->status_register="ERRSLV1STAT";
    guard_error_status_t ERRSLV1STAT @ 0xFFDDD404;
    guard_error_status_t ERRSLV1TYPE @ 0xFFDDD40C;
    ERRSLV1TYPE->source_ref="R01UH0585EJ0120 Table31.171";
    guard_error_clear_byte_t ERRSLV2CTL @ 0xFFF94400;
    ERRSLV2CTL->status_register="ERRSLV2STAT";
    guard_error_status_t ERRSLV2STAT @ 0xFFF94404;
    guard_error_status_t ERRSLV2TYPE @ 0xFFF9440C;
    ERRSLV2TYPE->source_ref="R01UH0585EJ0120 Table31.171";
    guard_error_clear_byte_t ERRSLV5CTL @ 0xFFC40400;
    ERRSLV5CTL->status_register="ERRSLV5STAT";
    guard_error_status_t ERRSLV5STAT @ 0xFFC40404;
    guard_error_status_t ERRSLV5TYPE @ 0xFFC4040C;
    ERRSLV5TYPE->source_ref="R01UH0585EJ0120 Table31.171";

    reg bus_guard_read_t {
        regwidth=32; accesswidth=8; access_widths="1,2,4"; behavior="bus-guard";
        trigger="guard-protection"; writable_mask=0x80240000;
        desc="P/H-bus read guard LOCK and PEID1/PEID4 permissions; all other bits retain reset";
        evidence="manual"; source_ref="R01UH0585EJ0120 Tables31.158-31.163,31.167,31.173";
        reset_classes="power-on,system-1-cvm,system-1-pin,system-2,application-1";
        field { sw=rw; reset=0x0605FE1B; } value[31:0];
    };
    reg bus_guard_write_t {
        regwidth=32; accesswidth=8; access_widths="1,2,4"; behavior="bus-guard";
        trigger="guard-protection"; writable_mask=0x80240000;
        desc="P/H-bus write guard LOCK and PEID1/PEID4 permissions; all other bits retain reset";
        evidence="manual"; source_ref="R01UH0585EJ0120 Tables31.158-31.163,31.167,31.174";
        reset_classes="power-on,system-1-cvm,system-1-pin,system-2,application-1";
        field { sw=rw; reset=0x0605FE17; } value[31:0];
    };
    bus_guard_read_t APBFSGDPROT_PDMACM_A @ 0xFFC4C000; APBFSGDPROT_PDMACM_A.value->reset=0x060DFE1B;
    guard_spid_t APBFSGDSPID_PDMACM_A @ 0xFFC4C004;
    bus_guard_write_t APBFSGDPROT_PDMACM_B @ 0xFFC4C008; APBFSGDPROT_PDMACM_B.value->reset=0x060DFE17;
    guard_spid_t APBFSGDSPID_PDMACM_B @ 0xFFC4C00C;
    bus_guard_read_t APBFSGDPROT_PDMACH_A @ 0xFFC4C010; APBFSGDPROT_PDMACH_A.value->reset=0x060DFE1B;
    guard_spid_t APBFSGDSPID_PDMACH_A @ 0xFFC4C014;
    bus_guard_write_t APBFSGDPROT_PDMACH_B @ 0xFFC4C018; APBFSGDPROT_PDMACH_B.value->reset=0x060DFE17;
    guard_spid_t APBFSGDSPID_PDMACH_B @ 0xFFC4C01C;
    bus_guard_read_t APBFSGDPROT_INTC2_A @ 0xFFC4C020; APBFSGDPROT_INTC2_A.value->reset=0x060DFE1B;
    guard_spid_t APBFSGDSPID_INTC2_A @ 0xFFC4C024;
    bus_guard_write_t APBFSGDPROT_INTC2_B @ 0xFFC4C028; APBFSGDPROT_INTC2_B.value->reset=0x060DFE17;
    guard_spid_t APBFSGDSPID_INTC2_B @ 0xFFC4C02C;
    bus_guard_read_t APBFSGDPROT_PBG_A @ 0xFFC4C040; APBFSGDPROT_PBG_A.value->reset=0x064DFE1B;
    guard_spid_t APBFSGDSPID_PBG_A @ 0xFFC4C044;
    bus_guard_write_t APBFSGDPROT_PBG_B @ 0xFFC4C048; APBFSGDPROT_PBG_B.value->reset=0x064DFE17;
    guard_spid_t APBFSGDSPID_PBG_B @ 0xFFC4C04C;
    bus_guard_read_t APBFSGDPROT_SP1_A @ 0xFFC4C050; APBFSGDPROT_SP1_A.value->reset=0x060DFE1B;
    guard_spid_t APBFSGDSPID_SP1_A @ 0xFFC4C054;
    bus_guard_write_t APBFSGDPROT_SP1_B @ 0xFFC4C058; APBFSGDPROT_SP1_B.value->reset=0x060DFE17;
    guard_spid_t APBFSGDSPID_SP1_B @ 0xFFC4C05C;
    bus_guard_read_t APBFSGDPROT_SP4_A @ 0xFFC4C070; APBFSGDPROT_SP4_A.value->reset=0x060DFE1B;
    guard_spid_t APBFSGDSPID_SP4_A @ 0xFFC4C074;
    bus_guard_write_t APBFSGDPROT_SP4_B @ 0xFFC4C078; APBFSGDPROT_SP4_B.value->reset=0x060DFE17;
    guard_spid_t APBFSGDSPID_SP4_B @ 0xFFC4C07C;
    bus_guard_read_t FSGD0PROT00 @ 0xFFC5A000;
    guard_spid_t FSGD0SPID00 @ 0xFFC5A004;
    bus_guard_write_t FSGD0PROT01 @ 0xFFC5A008;
    guard_spid_t FSGD0SPID01 @ 0xFFC5A00C;
    bus_guard_read_t FSGD0PROT04 @ 0xFFC5A020;
    guard_spid_t FSGD0SPID04 @ 0xFFC5A024;
    bus_guard_write_t FSGD0PROT05 @ 0xFFC5A028;
    guard_spid_t FSGD0SPID05 @ 0xFFC5A02C;
    bus_guard_read_t FSGD0PROT06 @ 0xFFC5A030;
    guard_spid_t FSGD0SPID06 @ 0xFFC5A034;
    bus_guard_write_t FSGD0PROT07 @ 0xFFC5A038;
    guard_spid_t FSGD0SPID07 @ 0xFFC5A03C;
    bus_guard_read_t FSGD0PROT10 @ 0xFFC5A050;
    guard_spid_t FSGD0SPID10 @ 0xFFC5A054;
    bus_guard_write_t FSGD0PROT11 @ 0xFFC5A058;
    guard_spid_t FSGD0SPID11 @ 0xFFC5A05C;

    reg gram_guard_prot_t {
        regwidth=32; accesswidth=8; access_widths="1,2,4"; behavior="gram-guard";
        trigger="gram-guard-protection"; writable_mask=0xC0000000;
        desc="Global-RAM write guard LOCK and EN; reserved bits must retain reset";
        evidence="manual"; source_ref="R01UH0585EJ0120 Tables31.149-31.153 section31.4.1.3";
        reset_classes="power-on,system-1-cvm,system-1-pin,system-2,application-1";
        field { sw=rw; reset=0x07FFFE10; } value[31:0];
    };
    reg gram_guard_address_t {
        regwidth=32; accesswidth=8; access_widths="1,2,4"; behavior="gram-guard";
        trigger="gram-guard-address"; writable_mask=0x001FFE00;
        desc="Global-RAM guard address/compare-valid bits20:9; 512-byte granularity";
        evidence="manual"; source_ref="R01UH0585EJ0120 Tables31.152-31.153 section31.4.1.3";
        reset_classes="power-on,system-1-cvm,system-1-pin,system-2,application-1";
        field { sw=rw; reset=0; } value[31:0];
    };
    gram_guard_prot_t MGDGRPROT0 @ 0xFFC49000;
    guard_spid_t MGDGRSPID0 @ 0xFFC49004; MGDGRSPID0->behavior="gram-guard";
    gram_guard_address_t MGDGRBAD0 @ 0xFFC49008;
    gram_guard_address_t MGDGRADV0 @ 0xFFC4900C;
    gram_guard_prot_t MGDGRPROT1 @ 0xFFC49010;
    guard_spid_t MGDGRSPID1 @ 0xFFC49014; MGDGRSPID1->behavior="gram-guard";
    gram_guard_address_t MGDGRBAD1 @ 0xFFC49018;
    gram_guard_address_t MGDGRADV1 @ 0xFFC4901C;
    gram_guard_prot_t MGDGRPROT2 @ 0xFFC49020;
    guard_spid_t MGDGRSPID2 @ 0xFFC49024; MGDGRSPID2->behavior="gram-guard";
    gram_guard_address_t MGDGRBAD2 @ 0xFFC49028;
    gram_guard_address_t MGDGRADV2 @ 0xFFC4902C;
    gram_guard_prot_t MGDGRPROT3 @ 0xFFC49030;
    guard_spid_t MGDGRSPID3 @ 0xFFC49034; MGDGRSPID3->behavior="gram-guard";
    gram_guard_address_t MGDGRBAD3 @ 0xFFC49038;
    gram_guard_address_t MGDGRADV3 @ 0xFFC4903C;
    gram_guard_prot_t MGDGRPROT4 @ 0xFFC49040;
    guard_spid_t MGDGRSPID4 @ 0xFFC49044; MGDGRSPID4->behavior="gram-guard";
    gram_guard_address_t MGDGRBAD4 @ 0xFFC49048;
    gram_guard_address_t MGDGRADV4 @ 0xFFC4904C;
    gram_guard_prot_t MGDGRPROT5 @ 0xFFC49050;
    guard_spid_t MGDGRSPID5 @ 0xFFC49054; MGDGRSPID5->behavior="gram-guard";
    gram_guard_address_t MGDGRBAD5 @ 0xFFC49058;
    gram_guard_address_t MGDGRADV5 @ 0xFFC4905C;
    gram_guard_prot_t MGDGRPROT6 @ 0xFFC49060;
    guard_spid_t MGDGRSPID6 @ 0xFFC49064; MGDGRSPID6->behavior="gram-guard";
    gram_guard_address_t MGDGRBAD6 @ 0xFFC49068;
    gram_guard_address_t MGDGRADV6 @ 0xFFC4906C;
    gram_guard_prot_t MGDGRPROT7 @ 0xFFC49070;
    guard_spid_t MGDGRSPID7 @ 0xFFC49074; MGDGRSPID7->behavior="gram-guard";
    gram_guard_address_t MGDGRBAD7 @ 0xFFC49078;
    gram_guard_address_t MGDGRADV7 @ 0xFFC4907C;
    bus_guard_read_t FSGDF0PROT00 @ 0xFFFA0000;
    guard_spid_t FSGDF0SPID00 @ 0xFFFA0004;
    bus_guard_write_t FSGDF0PROT01 @ 0xFFFA0008;
    guard_spid_t FSGDF0SPID01 @ 0xFFFA000C;
    bus_guard_read_t FSGD1APROT00 @ 0xFFDDD000; guard_spid_t FSGD1ASPID00 @ 0xFFDDD004;
    bus_guard_write_t FSGD1APROT01 @ 0xFFDDD008; guard_spid_t FSGD1ASPID01 @ 0xFFDDD00C;
    bus_guard_read_t FSGD1APROT02 @ 0xFFDDD010; guard_spid_t FSGD1ASPID02 @ 0xFFDDD014;
    bus_guard_write_t FSGD1APROT03 @ 0xFFDDD018; guard_spid_t FSGD1ASPID03 @ 0xFFDDD01C;
    bus_guard_read_t FSGD1APROT04 @ 0xFFDDD020; guard_spid_t FSGD1ASPID04 @ 0xFFDDD024;
    bus_guard_write_t FSGD1APROT05 @ 0xFFDDD028; guard_spid_t FSGD1ASPID05 @ 0xFFDDD02C;
    bus_guard_read_t FSGD1APROT06 @ 0xFFDDD030; guard_spid_t FSGD1ASPID06 @ 0xFFDDD034;
    bus_guard_write_t FSGD1APROT07 @ 0xFFDDD038; guard_spid_t FSGD1ASPID07 @ 0xFFDDD03C;
    bus_guard_read_t FSGD1APROT08 @ 0xFFDDD040; guard_spid_t FSGD1ASPID08 @ 0xFFDDD044;
    bus_guard_write_t FSGD1APROT09 @ 0xFFDDD048; guard_spid_t FSGD1ASPID09 @ 0xFFDDD04C;
    bus_guard_read_t FSGD1APROT10 @ 0xFFDDD050; guard_spid_t FSGD1ASPID10 @ 0xFFDDD054;
    bus_guard_write_t FSGD1APROT11 @ 0xFFDDD058; guard_spid_t FSGD1ASPID11 @ 0xFFDDD05C;
    bus_guard_read_t FSGD1APROT12 @ 0xFFDDD060; guard_spid_t FSGD1ASPID12 @ 0xFFDDD064;
    bus_guard_write_t FSGD1APROT13 @ 0xFFDDD068; guard_spid_t FSGD1ASPID13 @ 0xFFDDD06C;
    bus_guard_read_t FSGD1APROT14 @ 0xFFDDD070; guard_spid_t FSGD1ASPID14 @ 0xFFDDD074;
    bus_guard_write_t FSGD1APROT15 @ 0xFFDDD078; guard_spid_t FSGD1ASPID15 @ 0xFFDDD07C;
    bus_guard_read_t FSGD1BPROT00 @ 0xFFDDD080; guard_spid_t FSGD1BSPID00 @ 0xFFDDD084;
    bus_guard_write_t FSGD1BPROT01 @ 0xFFDDD088; guard_spid_t FSGD1BSPID01 @ 0xFFDDD08C;
    bus_guard_read_t FSGD1BPROT02 @ 0xFFDDD090; guard_spid_t FSGD1BSPID02 @ 0xFFDDD094;
    bus_guard_write_t FSGD1BPROT03 @ 0xFFDDD098; guard_spid_t FSGD1BSPID03 @ 0xFFDDD09C;
    bus_guard_read_t FSGD1BPROT04 @ 0xFFDDD0A0; guard_spid_t FSGD1BSPID04 @ 0xFFDDD0A4;
    bus_guard_write_t FSGD1BPROT05 @ 0xFFDDD0A8; guard_spid_t FSGD1BSPID05 @ 0xFFDDD0AC;
    bus_guard_read_t FSGD1BPROT06 @ 0xFFDDD0B0; guard_spid_t FSGD1BSPID06 @ 0xFFDDD0B4;
    bus_guard_write_t FSGD1BPROT07 @ 0xFFDDD0B8; guard_spid_t FSGD1BSPID07 @ 0xFFDDD0BC;
    bus_guard_read_t FSGD1BPROT08 @ 0xFFDDD0C0; guard_spid_t FSGD1BSPID08 @ 0xFFDDD0C4;
    bus_guard_write_t FSGD1BPROT09 @ 0xFFDDD0C8; guard_spid_t FSGD1BSPID09 @ 0xFFDDD0CC;
    bus_guard_read_t FSGD1BPROT10 @ 0xFFDDD0D0; guard_spid_t FSGD1BSPID10 @ 0xFFDDD0D4;
    bus_guard_write_t FSGD1BPROT11 @ 0xFFDDD0D8; guard_spid_t FSGD1BSPID11 @ 0xFFDDD0DC;
    bus_guard_read_t FSGD1BPROT12 @ 0xFFDDD0E0; guard_spid_t FSGD1BSPID12 @ 0xFFDDD0E4;
    bus_guard_write_t FSGD1BPROT13 @ 0xFFDDD0E8; guard_spid_t FSGD1BSPID13 @ 0xFFDDD0EC;
    bus_guard_read_t FSGD1BPROT14 @ 0xFFDDD0F0; guard_spid_t FSGD1BSPID14 @ 0xFFDDD0F4;
    bus_guard_write_t FSGD1BPROT15 @ 0xFFDDD0F8; guard_spid_t FSGD1BSPID15 @ 0xFFDDD0FC;
    bus_guard_read_t FSGD1CPROT00 @ 0xFFDDD100; guard_spid_t FSGD1CSPID00 @ 0xFFDDD104;
    bus_guard_write_t FSGD1CPROT01 @ 0xFFDDD108; guard_spid_t FSGD1CSPID01 @ 0xFFDDD10C;
    bus_guard_read_t FSGD1CPROT02 @ 0xFFDDD110; guard_spid_t FSGD1CSPID02 @ 0xFFDDD114;
    bus_guard_write_t FSGD1CPROT03 @ 0xFFDDD118; guard_spid_t FSGD1CSPID03 @ 0xFFDDD11C;
    bus_guard_read_t FSGD1CPROT04 @ 0xFFDDD120; guard_spid_t FSGD1CSPID04 @ 0xFFDDD124;
    bus_guard_write_t FSGD1CPROT05 @ 0xFFDDD128; guard_spid_t FSGD1CSPID05 @ 0xFFDDD12C;
    bus_guard_read_t FSGD1CPROT06 @ 0xFFDDD130; guard_spid_t FSGD1CSPID06 @ 0xFFDDD134;
    bus_guard_write_t FSGD1CPROT07 @ 0xFFDDD138; guard_spid_t FSGD1CSPID07 @ 0xFFDDD13C;
    bus_guard_read_t FSGD1CPROT08 @ 0xFFDDD140; guard_spid_t FSGD1CSPID08 @ 0xFFDDD144;
    bus_guard_write_t FSGD1CPROT09 @ 0xFFDDD148; guard_spid_t FSGD1CSPID09 @ 0xFFDDD14C;
    bus_guard_read_t FSGD1CPROT10 @ 0xFFDDD150; guard_spid_t FSGD1CSPID10 @ 0xFFDDD154;
    bus_guard_write_t FSGD1CPROT11 @ 0xFFDDD158; guard_spid_t FSGD1CSPID11 @ 0xFFDDD15C;
    bus_guard_read_t FSGD1CPROT12 @ 0xFFDDD160; guard_spid_t FSGD1CSPID12 @ 0xFFDDD164;
    bus_guard_write_t FSGD1CPROT13 @ 0xFFDDD168; guard_spid_t FSGD1CSPID13 @ 0xFFDDD16C;
    bus_guard_read_t FSGD1CPROT14 @ 0xFFDDD170; guard_spid_t FSGD1CSPID14 @ 0xFFDDD174;
    bus_guard_write_t FSGD1CPROT15 @ 0xFFDDD178; guard_spid_t FSGD1CSPID15 @ 0xFFDDD17C;
    bus_guard_read_t FSGD1DPROT00 @ 0xFFDDD180; guard_spid_t FSGD1DSPID00 @ 0xFFDDD184;
    bus_guard_write_t FSGD1DPROT01 @ 0xFFDDD188; guard_spid_t FSGD1DSPID01 @ 0xFFDDD18C;
    bus_guard_read_t FSGD1DPROT02 @ 0xFFDDD190; guard_spid_t FSGD1DSPID02 @ 0xFFDDD194;
    bus_guard_write_t FSGD1DPROT03 @ 0xFFDDD198; guard_spid_t FSGD1DSPID03 @ 0xFFDDD19C;
    bus_guard_read_t FSGD1DPROT04 @ 0xFFDDD1A0; guard_spid_t FSGD1DSPID04 @ 0xFFDDD1A4;
    bus_guard_write_t FSGD1DPROT05 @ 0xFFDDD1A8; guard_spid_t FSGD1DSPID05 @ 0xFFDDD1AC;
    bus_guard_read_t FSGD1DPROT06 @ 0xFFDDD1B0; guard_spid_t FSGD1DSPID06 @ 0xFFDDD1B4;
    bus_guard_write_t FSGD1DPROT07 @ 0xFFDDD1B8; guard_spid_t FSGD1DSPID07 @ 0xFFDDD1BC;
    bus_guard_read_t FSGD1DPROT08 @ 0xFFDDD1C0; guard_spid_t FSGD1DSPID08 @ 0xFFDDD1C4;
    bus_guard_write_t FSGD1DPROT09 @ 0xFFDDD1C8; guard_spid_t FSGD1DSPID09 @ 0xFFDDD1CC;
    bus_guard_read_t FSGD1DPROT10 @ 0xFFDDD1D0; guard_spid_t FSGD1DSPID10 @ 0xFFDDD1D4;
    bus_guard_write_t FSGD1DPROT11 @ 0xFFDDD1D8; guard_spid_t FSGD1DSPID11 @ 0xFFDDD1DC;
    bus_guard_read_t FSGD1DPROT12 @ 0xFFDDD1E0; guard_spid_t FSGD1DSPID12 @ 0xFFDDD1E4;
    bus_guard_write_t FSGD1DPROT13 @ 0xFFDDD1E8; guard_spid_t FSGD1DSPID13 @ 0xFFDDD1EC;
    bus_guard_read_t FSGD1DPROT14 @ 0xFFDDD1F0; guard_spid_t FSGD1DSPID14 @ 0xFFDDD1F4;
    bus_guard_write_t FSGD1DPROT15 @ 0xFFDDD1F8; guard_spid_t FSGD1DSPID15 @ 0xFFDDD1FC;
    bus_guard_read_t FSGD1EPROT00 @ 0xFFDDD200; guard_spid_t FSGD1ESPID00 @ 0xFFDDD204;
    bus_guard_write_t FSGD1EPROT01 @ 0xFFDDD208; guard_spid_t FSGD1ESPID01 @ 0xFFDDD20C;
    bus_guard_read_t FSGD1EPROT02 @ 0xFFDDD210; guard_spid_t FSGD1ESPID02 @ 0xFFDDD214;
    bus_guard_write_t FSGD1EPROT03 @ 0xFFDDD218; guard_spid_t FSGD1ESPID03 @ 0xFFDDD21C;
    bus_guard_read_t FSGD1EPROT04 @ 0xFFDDD220; guard_spid_t FSGD1ESPID04 @ 0xFFDDD224;
    bus_guard_write_t FSGD1EPROT05 @ 0xFFDDD228; guard_spid_t FSGD1ESPID05 @ 0xFFDDD22C;
    bus_guard_read_t FSGD1EPROT06 @ 0xFFDDD230; guard_spid_t FSGD1ESPID06 @ 0xFFDDD234;
    bus_guard_write_t FSGD1EPROT07 @ 0xFFDDD238; guard_spid_t FSGD1ESPID07 @ 0xFFDDD23C;
    bus_guard_read_t FSGD1EPROT08 @ 0xFFDDD240; guard_spid_t FSGD1ESPID08 @ 0xFFDDD244;
    bus_guard_write_t FSGD1EPROT09 @ 0xFFDDD248; guard_spid_t FSGD1ESPID09 @ 0xFFDDD24C;
    bus_guard_read_t FSGD1EPROT10 @ 0xFFDDD250; guard_spid_t FSGD1ESPID10 @ 0xFFDDD254;
    bus_guard_write_t FSGD1EPROT11 @ 0xFFDDD258; guard_spid_t FSGD1ESPID11 @ 0xFFDDD25C;
    bus_guard_read_t FSGD1EPROT12 @ 0xFFDDD260; guard_spid_t FSGD1ESPID12 @ 0xFFDDD264;
    bus_guard_write_t FSGD1EPROT13 @ 0xFFDDD268; guard_spid_t FSGD1ESPID13 @ 0xFFDDD26C;
    bus_guard_read_t FSGD1EPROT14 @ 0xFFDDD270; guard_spid_t FSGD1ESPID14 @ 0xFFDDD274;
    bus_guard_write_t FSGD1EPROT15 @ 0xFFDDD278; guard_spid_t FSGD1ESPID15 @ 0xFFDDD27C;
    bus_guard_read_t FSGD2APROT00 @ 0xFFF94000; guard_spid_t FSGD2ASPID00 @ 0xFFF94004;
    bus_guard_write_t FSGD2APROT01 @ 0xFFF94008; guard_spid_t FSGD2ASPID01 @ 0xFFF9400C;
    bus_guard_read_t FSGD2APROT02 @ 0xFFF94010; guard_spid_t FSGD2ASPID02 @ 0xFFF94014;
    bus_guard_write_t FSGD2APROT03 @ 0xFFF94018; guard_spid_t FSGD2ASPID03 @ 0xFFF9401C;
    bus_guard_read_t FSGD2APROT04 @ 0xFFF94020; guard_spid_t FSGD2ASPID04 @ 0xFFF94024;
    bus_guard_write_t FSGD2APROT05 @ 0xFFF94028; guard_spid_t FSGD2ASPID05 @ 0xFFF9402C;
    bus_guard_read_t FSGD2APROT06 @ 0xFFF94030; guard_spid_t FSGD2ASPID06 @ 0xFFF94034;
    bus_guard_write_t FSGD2APROT07 @ 0xFFF94038; guard_spid_t FSGD2ASPID07 @ 0xFFF9403C;
    bus_guard_read_t FSGD2APROT08 @ 0xFFF94040; guard_spid_t FSGD2ASPID08 @ 0xFFF94044;
    bus_guard_write_t FSGD2APROT09 @ 0xFFF94048; guard_spid_t FSGD2ASPID09 @ 0xFFF9404C;
    bus_guard_read_t FSGD2APROT10 @ 0xFFF94050; guard_spid_t FSGD2ASPID10 @ 0xFFF94054;
    bus_guard_write_t FSGD2APROT11 @ 0xFFF94058; guard_spid_t FSGD2ASPID11 @ 0xFFF9405C;
    bus_guard_read_t FSGD2APROT12 @ 0xFFF94060; guard_spid_t FSGD2ASPID12 @ 0xFFF94064;
    bus_guard_write_t FSGD2APROT13 @ 0xFFF94068; guard_spid_t FSGD2ASPID13 @ 0xFFF9406C;
    bus_guard_read_t FSGD2APROT14 @ 0xFFF94070; guard_spid_t FSGD2ASPID14 @ 0xFFF94074;
    bus_guard_write_t FSGD2APROT15 @ 0xFFF94078; guard_spid_t FSGD2ASPID15 @ 0xFFF9407C;
    bus_guard_read_t FSGD2BPROT00 @ 0xFFF94080; guard_spid_t FSGD2BSPID00 @ 0xFFF94084;
    bus_guard_write_t FSGD2BPROT01 @ 0xFFF94088; guard_spid_t FSGD2BSPID01 @ 0xFFF9408C;
    bus_guard_read_t FSGD2BPROT02 @ 0xFFF94090; guard_spid_t FSGD2BSPID02 @ 0xFFF94094;
    bus_guard_write_t FSGD2BPROT03 @ 0xFFF94098; guard_spid_t FSGD2BSPID03 @ 0xFFF9409C;
    bus_guard_read_t FSGD2BPROT04 @ 0xFFF940A0; guard_spid_t FSGD2BSPID04 @ 0xFFF940A4;
    bus_guard_write_t FSGD2BPROT05 @ 0xFFF940A8; guard_spid_t FSGD2BSPID05 @ 0xFFF940AC;
    bus_guard_read_t FSGD2BPROT06 @ 0xFFF940B0; guard_spid_t FSGD2BSPID06 @ 0xFFF940B4;
    bus_guard_write_t FSGD2BPROT07 @ 0xFFF940B8; guard_spid_t FSGD2BSPID07 @ 0xFFF940BC;
    bus_guard_read_t FSGD2BPROT08 @ 0xFFF940C0; guard_spid_t FSGD2BSPID08 @ 0xFFF940C4;
    bus_guard_write_t FSGD2BPROT09 @ 0xFFF940C8; guard_spid_t FSGD2BSPID09 @ 0xFFF940CC;
    bus_guard_read_t FSGD2BPROT10 @ 0xFFF940D0; guard_spid_t FSGD2BSPID10 @ 0xFFF940D4;
    bus_guard_write_t FSGD2BPROT11 @ 0xFFF940D8; guard_spid_t FSGD2BSPID11 @ 0xFFF940DC;
    bus_guard_read_t FSGD2BPROT12 @ 0xFFF940E0; guard_spid_t FSGD2BSPID12 @ 0xFFF940E4;
    bus_guard_write_t FSGD2BPROT13 @ 0xFFF940E8; guard_spid_t FSGD2BSPID13 @ 0xFFF940EC;
    bus_guard_read_t FSGD2CPROT00 @ 0xFFF94100; guard_spid_t FSGD2CSPID00 @ 0xFFF94104;
    bus_guard_write_t FSGD2CPROT01 @ 0xFFF94108; guard_spid_t FSGD2CSPID01 @ 0xFFF9410C;
    bus_guard_read_t FSGD2CPROT02 @ 0xFFF94110; guard_spid_t FSGD2CSPID02 @ 0xFFF94114;
    bus_guard_write_t FSGD2CPROT03 @ 0xFFF94118; guard_spid_t FSGD2CSPID03 @ 0xFFF9411C;
    bus_guard_read_t FSGD2CPROT04 @ 0xFFF94120; guard_spid_t FSGD2CSPID04 @ 0xFFF94124;
    bus_guard_write_t FSGD2CPROT05 @ 0xFFF94128; guard_spid_t FSGD2CSPID05 @ 0xFFF9412C;
    bus_guard_read_t FSGD2CPROT06 @ 0xFFF94130; guard_spid_t FSGD2CSPID06 @ 0xFFF94134;
    bus_guard_write_t FSGD2CPROT07 @ 0xFFF94138; guard_spid_t FSGD2CSPID07 @ 0xFFF9413C;
    bus_guard_read_t FSGD2CPROT08 @ 0xFFF94140; guard_spid_t FSGD2CSPID08 @ 0xFFF94144;
    bus_guard_write_t FSGD2CPROT09 @ 0xFFF94148; guard_spid_t FSGD2CSPID09 @ 0xFFF9414C;
    bus_guard_read_t FSGD2CPROT10 @ 0xFFF94150; guard_spid_t FSGD2CSPID10 @ 0xFFF94154;
    bus_guard_write_t FSGD2CPROT11 @ 0xFFF94158; guard_spid_t FSGD2CSPID11 @ 0xFFF9415C;
    bus_guard_read_t FSGD5APROT00 @ 0xFFC40000; guard_spid_t FSGD5ASPID00 @ 0xFFC40004;
    bus_guard_write_t FSGD5APROT01 @ 0xFFC40008; guard_spid_t FSGD5ASPID01 @ 0xFFC4000C;
    bus_guard_read_t FSGD5APROT02 @ 0xFFC40010; guard_spid_t FSGD5ASPID02 @ 0xFFC40014;
    bus_guard_write_t FSGD5APROT03 @ 0xFFC40018; guard_spid_t FSGD5ASPID03 @ 0xFFC4001C;
    bus_guard_read_t FSGD5APROT04 @ 0xFFC40020; guard_spid_t FSGD5ASPID04 @ 0xFFC40024;
    bus_guard_write_t FSGD5APROT05 @ 0xFFC40028; guard_spid_t FSGD5ASPID05 @ 0xFFC4002C;
    bus_guard_read_t FSGD5APROT06 @ 0xFFC40030; guard_spid_t FSGD5ASPID06 @ 0xFFC40034;
    bus_guard_write_t FSGD5APROT07 @ 0xFFC40038; guard_spid_t FSGD5ASPID07 @ 0xFFC4003C;
    bus_guard_read_t FSGD5APROT08 @ 0xFFC40040; guard_spid_t FSGD5ASPID08 @ 0xFFC40044;
    bus_guard_write_t FSGD5APROT09 @ 0xFFC40048; guard_spid_t FSGD5ASPID09 @ 0xFFC4004C;
    bus_guard_read_t FSGD5APROT10 @ 0xFFC40050; guard_spid_t FSGD5ASPID10 @ 0xFFC40054;
    bus_guard_write_t FSGD5APROT11 @ 0xFFC40058; guard_spid_t FSGD5ASPID11 @ 0xFFC4005C;
    bus_guard_read_t FSGD5APROT12 @ 0xFFC40060; guard_spid_t FSGD5ASPID12 @ 0xFFC40064;
    bus_guard_write_t FSGD5APROT13 @ 0xFFC40068; guard_spid_t FSGD5ASPID13 @ 0xFFC4006C;
    bus_guard_read_t FSGD5APROT14 @ 0xFFC40070; guard_spid_t FSGD5ASPID14 @ 0xFFC40074;
    bus_guard_write_t FSGD5APROT15 @ 0xFFC40078; guard_spid_t FSGD5ASPID15 @ 0xFFC4007C;
    bus_guard_read_t FSGD5BPROT00 @ 0xFFC40080; guard_spid_t FSGD5BSPID00 @ 0xFFC40084;
    bus_guard_write_t FSGD5BPROT01 @ 0xFFC40088; guard_spid_t FSGD5BSPID01 @ 0xFFC4008C;
    bus_guard_read_t FSGD5BPROT02 @ 0xFFC40090; guard_spid_t FSGD5BSPID02 @ 0xFFC40094;
    bus_guard_write_t FSGD5BPROT03 @ 0xFFC40098; guard_spid_t FSGD5BSPID03 @ 0xFFC4009C;
    bus_guard_read_t FSGD5BPROT06 @ 0xFFC400B0; guard_spid_t FSGD5BSPID06 @ 0xFFC400B4;
    bus_guard_write_t FSGD5BPROT07 @ 0xFFC400B8; guard_spid_t FSGD5BSPID07 @ 0xFFC400BC;
    bus_guard_read_t FSGD5BPROT08 @ 0xFFC400C0; guard_spid_t FSGD5BSPID08 @ 0xFFC400C4;
    bus_guard_write_t FSGD5BPROT09 @ 0xFFC400C8; guard_spid_t FSGD5BSPID09 @ 0xFFC400CC;
    bus_guard_read_t FSGD5BPROT10 @ 0xFFC400D0; guard_spid_t FSGD5BSPID10 @ 0xFFC400D4;
    bus_guard_write_t FSGD5BPROT11 @ 0xFFC400D8; guard_spid_t FSGD5BSPID11 @ 0xFFC400DC;
    bus_guard_read_t FSGD5BPROT12 @ 0xFFC400E0; guard_spid_t FSGD5BSPID12 @ 0xFFC400E4;
    bus_guard_write_t FSGD5BPROT13 @ 0xFFC400E8; guard_spid_t FSGD5BSPID13 @ 0xFFC400EC;
    bus_guard_read_t FSGD5BPROT14 @ 0xFFC400F0; guard_spid_t FSGD5BSPID14 @ 0xFFC400F4;
    bus_guard_write_t FSGD5BPROT15 @ 0xFFC400F8; guard_spid_t FSGD5BSPID15 @ 0xFFC400FC;
    bus_guard_read_t FSGD5CPROT00 @ 0xFFC40100; guard_spid_t FSGD5CSPID00 @ 0xFFC40104;
    bus_guard_write_t FSGD5CPROT01 @ 0xFFC40108; guard_spid_t FSGD5CSPID01 @ 0xFFC4010C;
    bus_guard_read_t FSGD5CPROT02 @ 0xFFC40110; guard_spid_t FSGD5CSPID02 @ 0xFFC40114;
    bus_guard_write_t FSGD5CPROT03 @ 0xFFC40118; guard_spid_t FSGD5CSPID03 @ 0xFFC4011C;
    bus_guard_read_t FSGD5CPROT04 @ 0xFFC40120; guard_spid_t FSGD5CSPID04 @ 0xFFC40124;
    bus_guard_write_t FSGD5CPROT05 @ 0xFFC40128; guard_spid_t FSGD5CSPID05 @ 0xFFC4012C;

    // Table31.157 reserves PBG0 channels8/9; they are not guard storage.
    // Table3.78 routes writes to unimplemented P-Bus area to SEG.VPGF.
    external mem {
        memwidth=8; mementries=0x10; sw=w; executable=false;
        evidence="manual"; source_ref="R01UH0585EJ0120 Tables31.157-31.158,3.78-3.81";
        reset_policy="unimplemented P-Bus area; writes fail without storing; SEG notification controls CPU exception";
    } pbg0_unimplemented_channels8_9 @ 0xFFC5A040;
    reg {
        regwidth=16; accesswidth=16; behavior="seg"; writable_mask=0x355;
        desc="SYSERR notification enable by error factor; no flag clears on acknowledgement";
        evidence="manual"; source_ref="R01UH0585EJ0120 Tables3.77-3.81 section3.2.3.3";
        reset_classes="power-on,system-1-cvm,system-1-pin,system-2,application-1";
        field { sw=rw; reset=0; } value[15:0];
    } SEGCONT @ 0xFFFEE980;
    reg {
        regwidth=16; accesswidth=16; behavior="seg"; writable_mask=0x354;
        desc="SYSERR error-response history; software can set and clear flags; setting alone does not notify; reserved bit5 reads undefined";
        evidence="manual"; source_ref="R01UH0585EJ0120 Tables3.77-3.81 section3.2.3.3";
        reset_classes="power-on,system-1-cvm,system-1-pin,system-2,application-1";
        reset_mask=0xFFDF;
        field { sw=rw; reset=0; } value[15:0];
    } SEGFLAG @ 0xFFFEE982;
    reg {
        regwidth=32; accesswidth=16; access_widths="2,4"; behavior="seg";
        writable_mask=0xFFFFFFFF;
        desc="First notification-enabled SYSERR error address; undefined/retained across reset, locked while enabled error flag is set";
        evidence="manual"; source_ref="R01UH0585EJ0120 Tables3.77,3.81 section3.2.3.3";
        field { sw=rw; } value[31:0];
    } SEGADDR @ 0xFFFEE988;
    // CPU-side IPG configuration. Enabled user-mode peripheral protection is
    // an explicit runtime boundary, not an ignored protection setting.
    reg {
        regwidth=8; accesswidth=8; desc="IPG user-mode protection enable and instruction-error recording control";
        evidence="manual"; source_ref="R01UH0585EJ0120 Tables3.68,3.71";
        behavior="ipg"; writable_mask=3;
        reset_classes="power-on,system-1-cvm,system-1-pin,system-2,application-1";
        field { sw=rw; reset=0; } value[7:0];
    } IPGENUM @ 0xFFFEE00D;
    reg {
        regwidth=8; accesswidth=8; desc="IPG peripheral-group user permissions";
        evidence="manual"; source_ref="R01UH0585EJ0120 Tables3.68,3.72";
        behavior="ipg"; writable_mask=0x70;
        reset_classes="power-on,system-1-cvm,system-1-pin,system-2,application-1";
        field { sw=rw; reset=0; } value[7:0];
    } IPGPMTUM0 @ 0xFFFEE020;
    reg {
        regwidth=8; accesswidth=8; desc="IPG global-RAM-bank user execution permissions";
        evidence="manual"; source_ref="R01UH0585EJ0120 Tables3.68,3.73";
        behavior="ipg"; writable_mask=0x44;
        reset_classes="power-on,system-1-cvm,system-1-pin,system-2,application-1";
        field { sw=rw; reset=0; } value[7:0];
    } IPGPMTUM1 @ 0xFFFEE021;
    reg {
        regwidth=8; accesswidth=8; desc="IPG INTC1 and COMPTEST user permissions";
        evidence="manual"; source_ref="R01UH0585EJ0120 Tables3.68,3.74";
        behavior="ipg"; writable_mask=0x33;
        reset_classes="power-on,system-1-cvm,system-1-pin,system-2,application-1";
        field { sw=rw; reset=0; } value[7:0];
    } IPGPMTUM2 @ 0xFFFEE022;
    reg {
        regwidth=8; accesswidth=8; desc="IPG SYSERRGen user permissions";
        evidence="manual"; source_ref="R01UH0585EJ0120 Tables3.68,3.75";
        behavior="ipg"; writable_mask=0x30;
        reset_classes="power-on,system-1-cvm,system-1-pin,system-2,application-1";
        field { sw=rw; reset=0; } value[7:0];
    } IPGPMTUM3 @ 0xFFFEE023;
    reg {
        regwidth=8; accesswidth=8; desc="IPG PEG and H-Bus user permissions";
        evidence="manual"; source_ref="R01UH0585EJ0120 Tables3.68,3.76";
        behavior="ipg"; writable_mask=0x73;
        reset_classes="power-on,system-1-cvm,system-1-pin,system-2,application-1";
        field { sw=rw; reset=0; } value[7:0];
    } IPGPMTUM4 @ 0xFFFEE024;

    // Functional memory is already write-through and has no cached GRAM
    // entries. These controls preserve register semantics without latency claims.
    reg {
        regwidth=32; accesswidth=32; desc="Global-RAM write-through buffer enable";
        evidence="manual"; source_ref="R01UH0585EJ0120 Tables3.82,3.83";
        behavior="gram-buffer"; writable_mask=1;
        reset_classes="power-on,system-1-cvm,system-1-pin,system-2,application-1";
        field { sw=rw; reset=1; } value[31:0];
    } GRAMCWTBCONFIG0 @ 0xFFFF7A04;
    reg {
        regwidth=32; accesswidth=32; desc="Global-RAM write-through buffer invalidation timer configuration";
        evidence="manual"; source_ref="R01UH0585EJ0120 Tables3.82,3.84";
        behavior="gram-buffer"; writable_mask=7;
        reset_classes="power-on,system-1-cvm,system-1-pin,system-2,application-1";
        field { sw=rw; reset=7; } value[31:0];
    } GRAMCWTBCONFIG1 @ 0xFFFF7A08;
    reg {
        regwidth=32; accesswidth=32; desc="Global-RAM write-through buffer invalidate-on-read; no cached entries in the functional model";
        evidence="manual"; source_ref="R01UH0585EJ0120 Tables3.82,3.85";
        behavior="gram-buffer"; read_value=0;
        field { sw=r; reset=0; } value[31:0];
    } GRAMCWTBCONFIG2 @ 0xFFFF7A0C;

    // Native JPPR0 remains 8-bit. Only the observed containing-halfword read
    // is additionally declared; native CS+ CPU execution zero-extends this read.
    // This does not assert silicon bus timing or general wider-SFR permission.
    reg {
        regwidth=8; accesswidth=8; access_widths="1,2";
        desc="JPPR0 six pin-input bits; explicitly declared halfword read zero-extends native value";
        evidence="manual+firmware";
        source_ref="R01UH0585EJ0120 section2.4.1.1 Table2.42 and section2.4.1.2(2); camry-8965F3307000 CodeFlash0x2CA; native CS+ CPU halfword-read observation";
        behavior="port-input"; active_mask=0x3F;
        field { sw=r; hw=w; reset=0; } value[7:0];
    } JPPR0 @ 0xFFC2000C;

    // Digital configuration only: no package pin voltages or analog behavior.
    // Tables2.36-2.42 define effective register bits (including reserved reset
    // ones in PM); package bonding does not create additional register bits.
    reg port8_t {
        regwidth=8; accesswidth=8; behavior="port-config";
        evidence="manual"; source_ref="R01UH0585EJ0120 Tables2.8,2.42";
        reset_classes="power-on,system-1-cvm,system-1-pin,system-2,application-1";
        field { sw=rw; reset=0; } value[7:0];
    };
    reg port16_t {
        regwidth=16; accesswidth=16; behavior="port-config";
        evidence="manual"; source_ref="R01UH0585EJ0120 Tables2.8,2.36-2.41";
        reset_classes="power-on,system-1-cvm,system-1-pin,system-2,application-1";
        field { sw=rw; reset=0; } value[15:0];
    };
    reg port32_t {
        regwidth=32; accesswidth=32; behavior="port-config";
        evidence="manual"; source_ref="R01UH0585EJ0120 Tables2.8,2.23,2.27-2.32,2.36-2.42";
        reset_classes="power-on,system-1-cvm,system-1-pin,system-2,application-1";
        field { sw=rw; reset=0; } value[31:0];
    };
    port16_t P0 @ 0xFFC10000; P0->writable_mask=0x7FFF;
    port16_t PM0 @ 0xFFC10010; PM0->writable_mask=0x7FFF; PM0.value->reset=0xFBFF;
    port16_t PMC0 @ 0xFFC10014; PMC0->writable_mask=0x7FFF;
    port16_t PFC0 @ 0xFFC10018; PFC0->writable_mask=0x7FFF;
    port16_t PFCE0 @ 0xFFC1001C; PFCE0->writable_mask=0x23FF;
    port16_t PFCAE0 @ 0xFFC10028; PFCAE0->writable_mask=0x3BFF;
    port32_t PINV0 @ 0xFFC10030; PINV0->writable_mask=0x7FFF;
    port16_t PIBC0 @ 0xFFC14000; PIBC0->writable_mask=0x7FFF;
    port16_t PBDC0 @ 0xFFC14004; PBDC0->writable_mask=0x7FFF;
    port16_t PIPC0 @ 0xFFC14008; PIPC0->writable_mask=0x7FFF;
    port16_t PU0 @ 0xFFC1400C; PU0->writable_mask=0x7FFF;
    port16_t PD0 @ 0xFFC14010; PD0->writable_mask=0x7FFF;
    port32_t PODC0 @ 0xFFC14014; PODC0->writable_mask=0x7FFF; PODC0.value->reset=0x400;
    port32_t PDSC0 @ 0xFFC14018; PDSC0->writable_mask=0x7FFF; PDSC0.value->reset=0x400;
    port32_t PUCC0 @ 0xFFC14028; PUCC0->writable_mask=0x7FFF;
    port16_t PISA0 @ 0xFFC1402C; PISA0->writable_mask=0x23F8; PISA0.value->reset=0x400;
    port32_t PODCE0 @ 0xFFC1403C; PODCE0->writable_mask=0x7FFF;
    port16_t P1 @ 0xFFC10040; P1->writable_mask=0x1F;
    port16_t PM1 @ 0xFFC10050; PM1->writable_mask=0x1F; PM1.value->reset=0xFFFF;
    port16_t PMC1 @ 0xFFC10054; PMC1->writable_mask=0x1F;
    port16_t PFC1 @ 0xFFC10058; PFC1->writable_mask=0x1F;
    port16_t PFCE1 @ 0xFFC1005C; PFCE1->writable_mask=0x1F;
    port16_t PFCAE1 @ 0xFFC10068; PFCAE1->writable_mask=0x1F;
    port32_t PINV1 @ 0xFFC10070; PINV1->writable_mask=0x1F;
    port16_t PIBC1 @ 0xFFC14040; PIBC1->writable_mask=0x1F;
    port16_t PBDC1 @ 0xFFC14044; PBDC1->writable_mask=0x1F;
    port16_t PIPC1 @ 0xFFC14048; PIPC1->writable_mask=0x18;
    port16_t PU1 @ 0xFFC1404C; PU1->writable_mask=0x1F;
    port16_t PD1 @ 0xFFC14050; PD1->writable_mask=0x1F;
    port32_t PODC1 @ 0xFFC14054; PODC1->writable_mask=0x1F;
    port32_t PDSC1 @ 0xFFC14058; PDSC1->writable_mask=0x1F;
    port32_t PUCC1 @ 0xFFC14068; PUCC1->writable_mask=0x1F;
    port16_t PISA1 @ 0xFFC1406C; PISA1->writable_mask=0x1E;
    port32_t PODCE1 @ 0xFFC1407C; PODCE1->writable_mask=0x1F;
    port16_t P2 @ 0xFFC10080; P2->writable_mask=0xFFFF;
    port16_t PM2 @ 0xFFC10090; PM2->writable_mask=0xFFFF; PM2.value->reset=0xFFFF;
    port16_t PMC2 @ 0xFFC10094; PMC2->writable_mask=0xFFFF;
    port16_t PFC2 @ 0xFFC10098; PFC2->writable_mask=0xFFFF;
    port16_t PFCE2 @ 0xFFC1009C; PFCE2->writable_mask=0xFFFF;
    port16_t PFCAE2 @ 0xFFC100A8; PFCAE2->writable_mask=0xFFFE;
    port32_t PINV2 @ 0xFFC100B0; PINV2->writable_mask=0xFFFF;
    port16_t PIBC2 @ 0xFFC14080; PIBC2->writable_mask=0xFFFF;
    port16_t PBDC2 @ 0xFFC14084; PBDC2->writable_mask=0xFFFF;
    port16_t PIPC2 @ 0xFFC14088; PIPC2->writable_mask=0x13EE;
    port16_t PU2 @ 0xFFC1408C; PU2->writable_mask=0xFFFF;
    port16_t PD2 @ 0xFFC14090; PD2->writable_mask=0xFFFF;
    port32_t PODC2 @ 0xFFC14094; PODC2->writable_mask=0xFFFF;
    port32_t PDSC2 @ 0xFFC14098; PDSC2->writable_mask=0xFFFF;
    port32_t PUCC2 @ 0xFFC140A8; PUCC2->writable_mask=0xFFFF;
    port16_t PISA2 @ 0xFFC140AC; PISA2->writable_mask=0x10A7;
    port32_t PODCE2 @ 0xFFC140BC; PODCE2->writable_mask=0xFFFF;
    port16_t P3 @ 0xFFC100C0; P3->writable_mask=0x7FFF;
    port16_t PM3 @ 0xFFC100D0; PM3->writable_mask=0x7FFF; PM3.value->reset=0xFFFF;
    port16_t PMC3 @ 0xFFC100D4; PMC3->writable_mask=0x7FFF;
    port16_t PFC3 @ 0xFFC100D8; PFC3->writable_mask=0x7FFF;
    port16_t PFCE3 @ 0xFFC100DC; PFCE3->writable_mask=0x7BFF;
    port16_t PFCAE3 @ 0xFFC100E8; PFCAE3->writable_mask=0x7FFF;
    port32_t PINV3 @ 0xFFC100F0; PINV3->writable_mask=0x7FFF;
    port16_t PIBC3 @ 0xFFC140C0; PIBC3->writable_mask=0x7FFF;
    port16_t PBDC3 @ 0xFFC140C4; PBDC3->writable_mask=0x7FFF;
    port16_t PIPC3 @ 0xFFC140C8; PIPC3->writable_mask=0x7F87;
    port16_t PU3 @ 0xFFC140CC; PU3->writable_mask=0x7FFF;
    port16_t PD3 @ 0xFFC140D0; PD3->writable_mask=0x7FFF;
    port32_t PODC3 @ 0xFFC140D4; PODC3->writable_mask=0x7FFF;
    port32_t PDSC3 @ 0xFFC140D8; PDSC3->writable_mask=0x7FFF;
    port32_t PUCC3 @ 0xFFC140E8; PUCC3->writable_mask=0x7FFF;
    port16_t PISA3 @ 0xFFC140EC; PISA3->writable_mask=0x4003;
    port32_t PODCE3 @ 0xFFC140FC; PODCE3->writable_mask=0x7FFF;
    port16_t P4 @ 0xFFC10100; P4->writable_mask=0x7FFF;
    port16_t PM4 @ 0xFFC10110; PM4->writable_mask=0x7FFF; PM4.value->reset=0xFFFF;
    port16_t PMC4 @ 0xFFC10114; PMC4->writable_mask=0x7FFF;
    port16_t PFC4 @ 0xFFC10118; PFC4->writable_mask=0x7FFF;
    port16_t PFCE4 @ 0xFFC1011C; PFCE4->writable_mask=0x7FFF;
    port16_t PFCAE4 @ 0xFFC10128; PFCAE4->writable_mask=0x7FFF;
    port32_t PINV4 @ 0xFFC10130; PINV4->writable_mask=0x7FFF;
    port16_t PIBC4 @ 0xFFC14100; PIBC4->writable_mask=0x7FFF;
    port16_t PBDC4 @ 0xFFC14104; PBDC4->writable_mask=0x7FFF;
    port16_t PIPC4 @ 0xFFC14108; PIPC4->writable_mask=0x7F;
    port16_t PU4 @ 0xFFC1410C; PU4->writable_mask=0x7FFF;
    port16_t PD4 @ 0xFFC14110; PD4->writable_mask=0x7FFF;
    port32_t PODC4 @ 0xFFC14114; PODC4->writable_mask=0x7FFF;
    port32_t PDSC4 @ 0xFFC14118; PDSC4->writable_mask=0x7FFF;
    port32_t PUCC4 @ 0xFFC14128; PUCC4->writable_mask=0x7FFF;
    port16_t PISA4 @ 0xFFC1412C; PISA4->writable_mask=0x367F;
    port32_t PODCE4 @ 0xFFC1413C; PODCE4->writable_mask=0x7FFF;
    port16_t P5 @ 0xFFC10140; P5->writable_mask=0xFFFF;
    port16_t PM5 @ 0xFFC10150; PM5->writable_mask=0xFFFF; PM5.value->reset=0xFFFF;
    port16_t PMC5 @ 0xFFC10154; PMC5->writable_mask=0xFFFF;
    port16_t PFC5 @ 0xFFC10158; PFC5->writable_mask=0xFFF7;
    port16_t PFCE5 @ 0xFFC1015C; PFCE5->writable_mask=0x7FFF;
    port16_t PFCAE5 @ 0xFFC10168; PFCAE5->writable_mask=0xFFFF;
    port32_t PINV5 @ 0xFFC10170; PINV5->writable_mask=0xFFFF;
    port16_t PIBC5 @ 0xFFC14140; PIBC5->writable_mask=0xFFFF;
    port16_t PBDC5 @ 0xFFC14144; PBDC5->writable_mask=0xFFFF;
    port16_t PIPC5 @ 0xFFC14148; PIPC5->writable_mask=0xFFF6;
    port16_t PU5 @ 0xFFC1414C; PU5->writable_mask=0xFFFF;
    port16_t PD5 @ 0xFFC14150; PD5->writable_mask=0xFFFF;
    port32_t PODC5 @ 0xFFC14154; PODC5->writable_mask=0xFFFF;
    port32_t PDSC5 @ 0xFFC14158; PDSC5->writable_mask=0xFFFF;
    port32_t PUCC5 @ 0xFFC14168; PUCC5->writable_mask=0xFFFF;
    port32_t PODCE5 @ 0xFFC1417C; PODCE5->writable_mask=0xFFFF;
    port8_t JP0 @ 0xFFC20000; JP0->writable_mask=0x2B;
    port8_t JPM0 @ 0xFFC20010; JPM0->writable_mask=0x2B; JPM0.value->reset=0xFF;
    port8_t JPMC0 @ 0xFFC20014; JPMC0->writable_mask=7;
    port8_t JPFCE0 @ 0xFFC2001C; JPFCE0->writable_mask=7;
    port8_t JPIBC0 @ 0xFFC24000; JPIBC0->writable_mask=0x2F;
    port8_t JPBDC0 @ 0xFFC24004; JPBDC0->writable_mask=0x2B;
    port8_t JPU0 @ 0xFFC2400C; JPU0->writable_mask=0x2F;
    port8_t JPD0 @ 0xFFC24010; JPD0->writable_mask=0x2F;
    port32_t JPODC0 @ 0xFFC24014; JPODC0->writable_mask=0x2B;
    port32_t JPDSC0 @ 0xFFC24018; JPDSC0->writable_mask=0x2B;
    port32_t JPUCC0 @ 0xFFC24028; JPUCC0->writable_mask=0x2B;
    port8_t JPISA0 @ 0xFFC2402C; JPISA0->writable_mask=0x2F;

    // Atomic write-enable aliases: upper halfword is a strobe, not storage.
    port32_t PSR0 @ 0xFFC10004; PSR0->trigger="port-masked-alias"; PSR0->control_register="P0";
    port32_t PMSR0 @ 0xFFC10020; PMSR0->trigger="port-masked-alias"; PMSR0->control_register="PM0";
    port32_t PMCSR0 @ 0xFFC10024; PMCSR0->trigger="port-masked-alias"; PMCSR0->control_register="PMC0";
    port32_t PSR1 @ 0xFFC10044; PSR1->trigger="port-masked-alias"; PSR1->control_register="P1";
    port32_t PMSR1 @ 0xFFC10060; PMSR1->trigger="port-masked-alias"; PMSR1->control_register="PM1";
    port32_t PMCSR1 @ 0xFFC10064; PMCSR1->trigger="port-masked-alias"; PMCSR1->control_register="PMC1";
    port32_t PSR2 @ 0xFFC10084; PSR2->trigger="port-masked-alias"; PSR2->control_register="P2";
    port32_t PMSR2 @ 0xFFC100A0; PMSR2->trigger="port-masked-alias"; PMSR2->control_register="PM2";
    port32_t PMCSR2 @ 0xFFC100A4; PMCSR2->trigger="port-masked-alias"; PMCSR2->control_register="PMC2";
    port32_t PSR3 @ 0xFFC100C4; PSR3->trigger="port-masked-alias"; PSR3->control_register="P3";
    port32_t PMSR3 @ 0xFFC100E0; PMSR3->trigger="port-masked-alias"; PMSR3->control_register="PM3";
    port32_t PMCSR3 @ 0xFFC100E4; PMCSR3->trigger="port-masked-alias"; PMCSR3->control_register="PMC3";
    port32_t PSR4 @ 0xFFC10104; PSR4->trigger="port-masked-alias"; PSR4->control_register="P4";
    port32_t PMSR4 @ 0xFFC10120; PMSR4->trigger="port-masked-alias"; PMSR4->control_register="PM4";
    port32_t PMCSR4 @ 0xFFC10124; PMCSR4->trigger="port-masked-alias"; PMCSR4->control_register="PMC4";
    port32_t PSR5 @ 0xFFC10144; PSR5->trigger="port-masked-alias"; PSR5->control_register="P5";
    port32_t PMSR5 @ 0xFFC10160; PMSR5->trigger="port-masked-alias"; PMSR5->control_register="PM5";
    port32_t PMCSR5 @ 0xFFC10164; PMCSR5->trigger="port-masked-alias"; PMCSR5->control_register="PMC5";
    port32_t JPSR0 @ 0xFFC20004; JPSR0->trigger="port-masked-alias"; JPSR0->control_register="JP0";
    port32_t JPMSR0 @ 0xFFC20020; JPMSR0->trigger="port-masked-alias"; JPMSR0->control_register="JPM0";
    port32_t JPMCSR0 @ 0xFFC20024; JPMCSR0->trigger="port-masked-alias"; JPMCSR0->control_register="JPMC0";

    reg port_input16_t {
        regwidth=16; accesswidth=16; behavior="port-input";
        evidence="manual"; source_ref="R01UH0585EJ0120 Tables2.36-2.41";
        field { sw=r; hw=w; reset=0; } value[15:0];
    };
    port_input16_t PPR0 @ 0xFFC1000C; PPR0->active_mask=0x7FFF;
    port_input16_t PPR1 @ 0xFFC1004C; PPR1->active_mask=0x1F;
    port_input16_t PPR2 @ 0xFFC1008C; PPR2->active_mask=0xFFFF;
    port_input16_t PPR3 @ 0xFFC100CC; PPR3->active_mask=0x7FFF;
    port_input16_t PPR4 @ 0xFFC1010C; PPR4->active_mask=0x7FFF;
    port_input16_t PPR5 @ 0xFFC1014C; PPR5->active_mask=0xFFFF;

    // Per-pin aliases of the effective group-register bits (Table2.32).
    // PINV/PODC/PODCE/PUCC/PDSC/PPR remain read-only through PCR.
    reg port_pin_t {
        regwidth=32; accesswidth=32; behavior="port-config"; trigger="port-pin-alias";
        evidence="manual"; source_ref="R01UH0585EJ0120 Tables2.32,2.36-2.42";
        reset_classes="power-on,system-1-cvm,system-1-pin,system-2,application-1";
        field { sw=rw; reset=0x10; } value[31:0];
    };
    port_pin_t PCR0_0 @ 0xFFC12000; PCR0_0->writable_mask=0x000F1077;
    port_pin_t PCR0_1 @ 0xFFC12004; PCR0_1->writable_mask=0x000F1077;
    port_pin_t PCR0_2 @ 0xFFC12008; PCR0_2->writable_mask=0x000F1077;
    port_pin_t PCR0_3 @ 0xFFC1200C; PCR0_3->writable_mask=0x004F1077;
    port_pin_t PCR0_4 @ 0xFFC12010; PCR0_4->writable_mask=0x004F1077;
    port_pin_t PCR0_5 @ 0xFFC12014; PCR0_5->writable_mask=0x004F1077;
    port_pin_t PCR0_6 @ 0xFFC12018; PCR0_6->writable_mask=0x004F1077;
    port_pin_t PCR0_7 @ 0xFFC1201C; PCR0_7->writable_mask=0x004F1077;
    port_pin_t PCR0_8 @ 0xFFC12020; PCR0_8->writable_mask=0x004F1077;
    port_pin_t PCR0_9 @ 0xFFC12024; PCR0_9->writable_mask=0x004F1077;
    port_pin_t PCR0_10 @ 0xFFC12028; PCR0_10->writable_mask=0x000F1071;
    PCR0_10.value->reset=0x11400000;
    port_pin_t PCR0_11 @ 0xFFC1202C; PCR0_11->writable_mask=0x000F1075;
    port_pin_t PCR0_12 @ 0xFFC12030; PCR0_12->writable_mask=0x000F1075;
    port_pin_t PCR0_13 @ 0xFFC12034; PCR0_13->writable_mask=0x004F1077;
    port_pin_t PCR0_14 @ 0xFFC12038; PCR0_14->writable_mask=0x000F1071;
    port_pin_t PCR1_0 @ 0xFFC12040; PCR1_0->writable_mask=0x000F1057;
    port_pin_t PCR1_1 @ 0xFFC12044; PCR1_1->writable_mask=0x004F1057;
    port_pin_t PCR1_2 @ 0xFFC12048; PCR1_2->writable_mask=0x004F1057;
    port_pin_t PCR1_3 @ 0xFFC1204C; PCR1_3->writable_mask=0x004F1077;
    port_pin_t PCR1_4 @ 0xFFC12050; PCR1_4->writable_mask=0x004F1077;
    port_pin_t PCR2_0 @ 0xFFC12080; PCR2_0->writable_mask=0x004F1053;
    port_pin_t PCR2_1 @ 0xFFC12084; PCR2_1->writable_mask=0x004F1077;
    port_pin_t PCR2_2 @ 0xFFC12088; PCR2_2->writable_mask=0x004F1077;
    port_pin_t PCR2_3 @ 0xFFC1208C; PCR2_3->writable_mask=0x000F1077;
    port_pin_t PCR2_4 @ 0xFFC12090; PCR2_4->writable_mask=0x000F1057;
    port_pin_t PCR2_5 @ 0xFFC12094; PCR2_5->writable_mask=0x004F1077;
    port_pin_t PCR2_6 @ 0xFFC12098; PCR2_6->writable_mask=0x000F1077;
    port_pin_t PCR2_7 @ 0xFFC1209C; PCR2_7->writable_mask=0x004F1077;
    port_pin_t PCR2_8 @ 0xFFC120A0; PCR2_8->writable_mask=0x000F1077;
    port_pin_t PCR2_9 @ 0xFFC120A4; PCR2_9->writable_mask=0x000F1077;
    port_pin_t PCR2_10 @ 0xFFC120A8; PCR2_10->writable_mask=0x000F1057;
    port_pin_t PCR2_11 @ 0xFFC120AC; PCR2_11->writable_mask=0x000F1057;
    port_pin_t PCR2_12 @ 0xFFC120B0; PCR2_12->writable_mask=0x004F1077;
    port_pin_t PCR2_13 @ 0xFFC120B4; PCR2_13->writable_mask=0x000F1057;
    port_pin_t PCR2_14 @ 0xFFC120B8; PCR2_14->writable_mask=0x000F1057;
    port_pin_t PCR2_15 @ 0xFFC120BC; PCR2_15->writable_mask=0x000F1057;
    port_pin_t PCR3_0 @ 0xFFC120C0; PCR3_0->writable_mask=0x004F1077;
    port_pin_t PCR3_1 @ 0xFFC120C4; PCR3_1->writable_mask=0x004F1077;
    port_pin_t PCR3_2 @ 0xFFC120C8; PCR3_2->writable_mask=0x000F1077;
    port_pin_t PCR3_3 @ 0xFFC120CC; PCR3_3->writable_mask=0x000F1057;
    port_pin_t PCR3_4 @ 0xFFC120D0; PCR3_4->writable_mask=0x000F1057;
    port_pin_t PCR3_5 @ 0xFFC120D4; PCR3_5->writable_mask=0x000F1057;
    port_pin_t PCR3_6 @ 0xFFC120D8; PCR3_6->writable_mask=0x000F1057;
    port_pin_t PCR3_7 @ 0xFFC120DC; PCR3_7->writable_mask=0x000F1077;
    port_pin_t PCR3_8 @ 0xFFC120E0; PCR3_8->writable_mask=0x000F1077;
    port_pin_t PCR3_9 @ 0xFFC120E4; PCR3_9->writable_mask=0x000F1077;
    port_pin_t PCR3_10 @ 0xFFC120E8; PCR3_10->writable_mask=0x000F1075;
    port_pin_t PCR3_11 @ 0xFFC120EC; PCR3_11->writable_mask=0x000F1077;
    port_pin_t PCR3_12 @ 0xFFC120F0; PCR3_12->writable_mask=0x000F1077;
    port_pin_t PCR3_13 @ 0xFFC120F4; PCR3_13->writable_mask=0x000F1077;
    port_pin_t PCR3_14 @ 0xFFC120F8; PCR3_14->writable_mask=0x004F1077;
    port_pin_t PCR4_0 @ 0xFFC12100; PCR4_0->writable_mask=0x004F1077;
    port_pin_t PCR4_1 @ 0xFFC12104; PCR4_1->writable_mask=0x004F1077;
    port_pin_t PCR4_2 @ 0xFFC12108; PCR4_2->writable_mask=0x004F1077;
    port_pin_t PCR4_3 @ 0xFFC1210C; PCR4_3->writable_mask=0x004F1077;
    port_pin_t PCR4_4 @ 0xFFC12110; PCR4_4->writable_mask=0x004F1077;
    port_pin_t PCR4_5 @ 0xFFC12114; PCR4_5->writable_mask=0x004F1077;
    port_pin_t PCR4_6 @ 0xFFC12118; PCR4_6->writable_mask=0x004F1077;
    port_pin_t PCR4_7 @ 0xFFC1211C; PCR4_7->writable_mask=0x000F1057;
    port_pin_t PCR4_8 @ 0xFFC12120; PCR4_8->writable_mask=0x000F1057;
    port_pin_t PCR4_9 @ 0xFFC12124; PCR4_9->writable_mask=0x004F1057;
    port_pin_t PCR4_10 @ 0xFFC12128; PCR4_10->writable_mask=0x004F1057;
    port_pin_t PCR4_11 @ 0xFFC1212C; PCR4_11->writable_mask=0x000F1057;
    port_pin_t PCR4_12 @ 0xFFC12130; PCR4_12->writable_mask=0x004F1057;
    port_pin_t PCR4_13 @ 0xFFC12134; PCR4_13->writable_mask=0x004F1057;
    port_pin_t PCR4_14 @ 0xFFC12138; PCR4_14->writable_mask=0x000F1057;
    port_pin_t PCR5_0 @ 0xFFC12140; PCR5_0->writable_mask=0x000F1057;
    port_pin_t PCR5_1 @ 0xFFC12144; PCR5_1->writable_mask=0x000F1077;
    port_pin_t PCR5_2 @ 0xFFC12148; PCR5_2->writable_mask=0x000F1077;
    port_pin_t PCR5_3 @ 0xFFC1214C; PCR5_3->writable_mask=0x000F1056;
    port_pin_t PCR5_4 @ 0xFFC12150; PCR5_4->writable_mask=0x000F1077;
    port_pin_t PCR5_5 @ 0xFFC12154; PCR5_5->writable_mask=0x000F1077;
    port_pin_t PCR5_6 @ 0xFFC12158; PCR5_6->writable_mask=0x000F1077;
    port_pin_t PCR5_7 @ 0xFFC1215C; PCR5_7->writable_mask=0x000F1077;
    port_pin_t PCR5_8 @ 0xFFC12160; PCR5_8->writable_mask=0x000F1077;
    port_pin_t PCR5_9 @ 0xFFC12164; PCR5_9->writable_mask=0x000F1077;
    port_pin_t PCR5_10 @ 0xFFC12168; PCR5_10->writable_mask=0x000F1077;
    port_pin_t PCR5_11 @ 0xFFC1216C; PCR5_11->writable_mask=0x000F1077;
    port_pin_t PCR5_12 @ 0xFFC12170; PCR5_12->writable_mask=0x000F1077;
    port_pin_t PCR5_13 @ 0xFFC12174; PCR5_13->writable_mask=0x000F1077;
    port_pin_t PCR5_14 @ 0xFFC12178; PCR5_14->writable_mask=0x000F1077;
    port_pin_t PCR5_15 @ 0xFFC1217C; PCR5_15->writable_mask=0x000F1075;
    port_pin_t JPCR0_0 @ 0xFFC22000; JPCR0_0->writable_mask=0x004F1052;
    port_pin_t JPCR0_1 @ 0xFFC22004; JPCR0_1->writable_mask=0x004F1052;
    port_pin_t JPCR0_2 @ 0xFFC22008; JPCR0_2->writable_mask=0x004D0042;
    port_pin_t JPCR0_3 @ 0xFFC2200C; JPCR0_3->writable_mask=0x004F1010;
    port_pin_t JPCR0_4 @ 0xFFC22010; JPCR0_4->writable_mask=0x00000000;
    port_pin_t JPCR0_5 @ 0xFFC22014; JPCR0_5->writable_mask=0x004F1010;

    // Noise-filter configuration is retained only while disabled. Enabling a
    // filter requires external signal/timing semantics outside this model.
    reg noise_ctl_t {
        regwidth=8; accesswidth=8; behavior="noise-filter"; writable_mask=0x67;
        evidence="manual"; source_ref="R01UH0585EJ0120 Tables2.50,2.53; section2.6.3 cautions";
        field { sw=rw; reset=0; } value[7:0];
    };
    reg noise_en_t {
        regwidth=16; accesswidth=16; behavior="noise-filter"; trigger="noise-filter-enable";
        evidence="manual"; source_ref="R01UH0585EJ0120 Tables2.50,2.54";
        field { sw=rw; reset=0; } value[15:0];
    };
    noise_ctl_t DNFA0CTL @ 0xFFC30000; DNFA0CTL->enable_register="DNFA0EN";
    noise_en_t DNFA0EN @ 0xFFC30004; DNFA0EN->writable_mask=7;
    noise_ctl_t DNFA1CTL @ 0xFFC30100; DNFA1CTL->enable_register="DNFA1EN";
    noise_en_t DNFA1EN @ 0xFFC30104; DNFA1EN->writable_mask=3;
    noise_ctl_t DNFA2CTL @ 0xFFC30200; DNFA2CTL->enable_register="DNFA2EN";
    noise_en_t DNFA2EN @ 0xFFC30204; DNFA2EN->writable_mask=0x1F;
    noise_ctl_t DNFA3CTL @ 0xFFC30300; DNFA3CTL->enable_register="DNFA3EN";
    noise_en_t DNFA3EN @ 0xFFC30304; DNFA3EN->writable_mask=3;
    noise_ctl_t DNFA4CTL @ 0xFFC30400; DNFA4CTL->enable_register="DNFA4EN";
    noise_en_t DNFA4EN @ 0xFFC30404; DNFA4EN->writable_mask=3;
    noise_ctl_t DNFA5CTL @ 0xFFC30500; DNFA5CTL->enable_register="DNFA5EN";
    noise_en_t DNFA5EN @ 0xFFC30504; DNFA5EN->writable_mask=3;
    noise_ctl_t DNFA6CTL @ 0xFFC30600; DNFA6CTL->enable_register="DNFA6EN";
    noise_en_t DNFA6EN @ 0xFFC30604; DNFA6EN->writable_mask=3;
    noise_ctl_t DNFA7CTL @ 0xFFC30700; DNFA7CTL->enable_register="DNFA7EN";
    noise_en_t DNFA7EN @ 0xFFC30704; DNFA7EN->writable_mask=3;
    noise_ctl_t DNFA8CTL @ 0xFFC30800; DNFA8CTL->enable_register="DNFA8EN";
    noise_en_t DNFA8EN @ 0xFFC30804; DNFA8EN->writable_mask=3;
    noise_ctl_t DNFA9CTL @ 0xFFC30900; DNFA9CTL->enable_register="DNFA9EN";
    noise_en_t DNFA9EN @ 0xFFC30904; DNFA9EN->writable_mask=0xFF;
    noise_ctl_t DNFA10CTL @ 0xFFC30A00; DNFA10CTL->enable_register="DNFA10EN";
    noise_en_t DNFA10EN @ 0xFFC30A04; DNFA10EN->writable_mask=3;
    noise_ctl_t DNFA11CTL @ 0xFFC30B00; DNFA11CTL->enable_register="DNFA11EN";
    noise_en_t DNFA11EN @ 0xFFC30B04; DNFA11EN->writable_mask=3;
    noise_ctl_t DNFA12CTL @ 0xFFC30C00; DNFA12CTL->enable_register="DNFA12EN";
    noise_en_t DNFA12EN @ 0xFFC30C04; DNFA12EN->writable_mask=3;
    noise_ctl_t DNFA13CTL @ 0xFFC30D00; DNFA13CTL->enable_register="DNFA13EN";
    noise_en_t DNFA13EN @ 0xFFC30D04; DNFA13EN->writable_mask=3;
    noise_ctl_t DNFA14CTL @ 0xFFC30E00; DNFA14CTL->enable_register="DNFA14EN";
    noise_en_t DNFA14EN @ 0xFFC30E04; DNFA14EN->writable_mask=0xFF;
    noise_ctl_t DNFA15CTL @ 0xFFC30F00; DNFA15CTL->enable_register="DNFA15EN";
    noise_en_t DNFA15EN @ 0xFFC30F04; DNFA15EN->writable_mask=3;
    noise_ctl_t DNFA16CTL @ 0xFFC31000; DNFA16CTL->enable_register="DNFA16EN";
    noise_en_t DNFA16EN @ 0xFFC31004; DNFA16EN->writable_mask=3;
    noise_ctl_t DNFA17CTL @ 0xFFC31100; DNFA17CTL->enable_register="DNFA17EN";
    noise_en_t DNFA17EN @ 0xFFC31104; DNFA17EN->writable_mask=3;
    noise_ctl_t DNFA18CTL @ 0xFFC31200; DNFA18CTL->enable_register="DNFA18EN";
    noise_en_t DNFA18EN @ 0xFFC31204; DNFA18EN->writable_mask=3;
    noise_ctl_t DNFA19CTL @ 0xFFC31300; DNFA19CTL->enable_register="DNFA19EN";
    noise_en_t DNFA19EN @ 0xFFC31304; DNFA19EN->writable_mask=0xFF;
    noise_ctl_t DNFA20CTL @ 0xFFC31400; DNFA20CTL->enable_register="DNFA20EN";
    noise_en_t DNFA20EN @ 0xFFC31404; DNFA20EN->writable_mask=1;
    noise_ctl_t DNFA21CTL @ 0xFFC31500; DNFA21CTL->enable_register="DNFA21EN";
    noise_en_t DNFA21EN @ 0xFFC31504; DNFA21EN->writable_mask=1;
    noise_ctl_t DNFA22CTL @ 0xFFC31600; DNFA22CTL->enable_register="DNFA22EN";
    noise_en_t DNFA22EN @ 0xFFC31604; DNFA22EN->writable_mask=1;
    noise_ctl_t DNFA23CTL @ 0xFFC31700; DNFA23CTL->enable_register="DNFA23EN";
    noise_en_t DNFA23EN @ 0xFFC31704; DNFA23EN->writable_mask=1;
    noise_ctl_t DNFA24CTL @ 0xFFC31800; DNFA24CTL->enable_register="DNFA24EN";
    noise_en_t DNFA24EN @ 0xFFC31804; DNFA24EN->writable_mask=1;
    noise_ctl_t DNFA25CTL @ 0xFFC31900; DNFA25CTL->enable_register="DNFA25EN";
    noise_en_t DNFA25EN @ 0xFFC31904; DNFA25EN->writable_mask=1;
    noise_ctl_t DNFA26CTL @ 0xFFC31A00; DNFA26CTL->enable_register="DNFA26EN";
    noise_en_t DNFA26EN @ 0xFFC31A04; DNFA26EN->writable_mask=1;
    noise_ctl_t DNFA27CTL @ 0xFFC31B00; DNFA27CTL->enable_register="DNFA27EN";
    noise_en_t DNFA27EN @ 0xFFC31B04; DNFA27EN->writable_mask=1;
    noise_ctl_t DNFA28CTL @ 0xFFC31C00; DNFA28CTL->enable_register="DNFA28EN";
    noise_en_t DNFA28EN @ 0xFFC31C04; DNFA28EN->writable_mask=1;
    noise_ctl_t DNFA29CTL @ 0xFFC31D00; DNFA29CTL->enable_register="DNFA29EN";
    noise_en_t DNFA29EN @ 0xFFC31D04; DNFA29EN->writable_mask=1;
    noise_ctl_t DNFA30CTL @ 0xFFC31E00; DNFA30CTL->enable_register="DNFA30EN";
    noise_en_t DNFA30EN @ 0xFFC31E04; DNFA30EN->writable_mask=1;
    noise_ctl_t DNFA31CTL @ 0xFFC31F00; DNFA31CTL->enable_register="DNFA31EN";
    noise_en_t DNFA31EN @ 0xFFC31F04; DNFA31EN->writable_mask=1;
    noise_ctl_t DNFA32CTL @ 0xFFC32000; DNFA32CTL->enable_register="DNFA32EN";
    noise_en_t DNFA32EN @ 0xFFC32004; DNFA32EN->writable_mask=3;
    noise_ctl_t DNFA33CTL @ 0xFFC32100; DNFA33CTL->enable_register="DNFA33EN";
    noise_en_t DNFA33EN @ 0xFFC32104; DNFA33EN->writable_mask=1;
    noise_ctl_t DNFA34CTL @ 0xFFC32200; DNFA34CTL->enable_register="DNFA34EN";
    noise_en_t DNFA34EN @ 0xFFC32204; DNFA34EN->writable_mask=1;
    noise_ctl_t DNFA35CTL @ 0xFFC32300; DNFA35CTL->enable_register="DNFA35EN";
    noise_en_t DNFA35EN @ 0xFFC32304; DNFA35EN->writable_mask=3;
    noise_ctl_t DNFA36CTL @ 0xFFC32400; DNFA36CTL->enable_register="DNFA36EN";
    noise_en_t DNFA36EN @ 0xFFC32404; DNFA36EN->writable_mask=1;
    noise_ctl_t DNFA37CTL @ 0xFFC32500; DNFA37CTL->enable_register="DNFA37EN";
    noise_en_t DNFA37EN @ 0xFFC32504; DNFA37EN->writable_mask=1;
    noise_ctl_t DNFA38CTL @ 0xFFC32600; DNFA38CTL->enable_register="DNFA38EN";
    noise_en_t DNFA38EN @ 0xFFC32604; DNFA38EN->writable_mask=3;
    noise_ctl_t DNFA39CTL @ 0xFFC32700; DNFA39CTL->enable_register="DNFA39EN";
    noise_en_t DNFA39EN @ 0xFFC32704; DNFA39EN->writable_mask=3;
    noise_ctl_t DNFA40CTL @ 0xFFC32800; DNFA40CTL->enable_register="DNFA40EN";
    noise_en_t DNFA40EN @ 0xFFC32804; DNFA40EN->writable_mask=0x1F;
    noise_ctl_t DNFA41CTL @ 0xFFC32900; DNFA41CTL->enable_register="DNFA41EN";
    noise_en_t DNFA41EN @ 0xFFC32904; DNFA41EN->writable_mask=3;
    noise_ctl_t DNFA42CTL @ 0xFFC32A00; DNFA42CTL->enable_register="DNFA42EN";
    noise_en_t DNFA42EN @ 0xFFC32A04; DNFA42EN->writable_mask=0x3F;
    noise_ctl_t DNFA43CTL @ 0xFFC32B00; DNFA43CTL->enable_register="DNFA43EN";
    noise_en_t DNFA43EN @ 0xFFC32B04; DNFA43EN->writable_mask=3;

    reg filter_ctl_t {
        regwidth=8; accesswidth=8; behavior="noise-filter";
        evidence="manual"; source_ref="R01UH0585EJ0120 Tables2.50,2.52";
        field { sw=rw; reset=0; } value[7:0];
    };
    filter_ctl_t FCLA0CTL0 @ 0xFFC34000; FCLA0CTL0->writable_mask=3; FCLA0CTL0->enable_register="DNFA4EN";
    filter_ctl_t FCLA1CTL0 @ 0xFFC34020; FCLA1CTL0->writable_mask=0x83; FCLA1CTL0->enable_register="DNFA0EN";
    filter_ctl_t FCLA1CTL1 @ 0xFFC34024; FCLA1CTL1->writable_mask=0x83; FCLA1CTL1->enable_register="DNFA0EN";
    filter_ctl_t FCLA1CTL2 @ 0xFFC34028; FCLA1CTL2->writable_mask=0x83; FCLA1CTL2->enable_register="DNFA0EN";
    filter_ctl_t FCLA1CTL3 @ 0xFFC3402C; FCLA1CTL3->writable_mask=0x83; FCLA1CTL3->enable_register="DNFA1EN";
    filter_ctl_t FCLA1CTL4 @ 0xFFC34030; FCLA1CTL4->writable_mask=0x83; FCLA1CTL4->enable_register="DNFA1EN";
    filter_ctl_t FCLA1CTL5 @ 0xFFC34034; FCLA1CTL5->writable_mask=0x83; FCLA1CTL5->enable_register="DNFA2EN";
    filter_ctl_t FCLA1CTL6 @ 0xFFC34038; FCLA1CTL6->writable_mask=0x83; FCLA1CTL6->enable_register="DNFA2EN";
    filter_ctl_t FCLA1CTL7 @ 0xFFC3403C; FCLA1CTL7->writable_mask=0x83; FCLA1CTL7->enable_register="DNFA3EN";
    filter_ctl_t FCLA2CTL0 @ 0xFFC34040; FCLA2CTL0->writable_mask=0x83; FCLA2CTL0->enable_register="DNFA3EN";
    filter_ctl_t FCLA2CTL1 @ 0xFFC34044; FCLA2CTL1->writable_mask=3; FCLA2CTL1->enable_register="DNFA4EN";
    filter_ctl_t FCLA2CTL2 @ 0xFFC34048; FCLA2CTL2->writable_mask=0x83; FCLA2CTL2->enable_register="DNFA2EN";
    filter_ctl_t FCLA2CTL3 @ 0xFFC3404C; FCLA2CTL3->writable_mask=0x83; FCLA2CTL3->enable_register="DNFA2EN";
    filter_ctl_t FCLA2CTL4 @ 0xFFC34050; FCLA2CTL4->writable_mask=0x83; FCLA2CTL4->enable_register="DNFA2EN";
    filter_ctl_t FCLA3CTL0 @ 0xFFC34060; FCLA3CTL0->writable_mask=0x80; FCLA3CTL0->enable_register="DNFA42EN";
    filter_ctl_t FCLA3CTL1 @ 0xFFC34064; FCLA3CTL1->writable_mask=0x80; FCLA3CTL1->enable_register="DNFA42EN";
    filter_ctl_t FCLA3CTL2 @ 0xFFC34068; FCLA3CTL2->writable_mask=0x80; FCLA3CTL2->enable_register="DNFA42EN";
    filter_ctl_t FCLA3CTL3 @ 0xFFC3406C; FCLA3CTL3->writable_mask=0x80; FCLA3CTL3->enable_register="DNFA42EN";
    filter_ctl_t FCLA3CTL4 @ 0xFFC34070; FCLA3CTL4->writable_mask=0x80; FCLA3CTL4->enable_register="DNFA42EN";
    filter_ctl_t FCLA3CTL5 @ 0xFFC34074; FCLA3CTL5->writable_mask=0x80; FCLA3CTL5->enable_register="DNFA42EN";
    filter_ctl_t FCLA4CTL0 @ 0xFFC34080; FCLA4CTL0->writable_mask=0x80; FCLA4CTL0->enable_register="DNFA43EN";
    filter_ctl_t FCLA4CTL1 @ 0xFFC34084; FCLA4CTL1->writable_mask=0x80; FCLA4CTL1->enable_register="DNFA43EN";

    // DNF has neither clock3's divider/SYNC protocol nor a readiness promise.
    // A changed source invalidates CLKACT until an explicit external input.
    reg noise_clock_t {
        regwidth=32; accesswidth=32; behavior="noise-filter"; trigger="noise-clock-selector";
        writable_mask=6; allowed_values="2,4";
        evidence="manual"; source_ref="R01UH0585EJ0120 Tables2.50,2.55,2.56";
        field { sw=rw; reset=2; } value[31:0];
    };
    reg noise_clock_status_t {
        regwidth=32; accesswidth=32; behavior="noise-clock-status";
        evidence="manual"; source_ref="R01UH0585EJ0120 Table2.56; CLKACT is not a fixed ready bit";
        field { sw=r; hw=w; reset=3; } value[31:0];
    };
    noise_clock_t DNFCKS100C @ 0xFFF89120; DNFCKS100C->status_register="DNFCSC100STAT"; DNFCKS100C->capture_registers="DNFA0EN,DNFA1EN,DNFA2EN,DNFA3EN,DNFA4EN";
    noise_clock_status_t DNFCSC100STAT @ 0xFFF89124;
    noise_clock_t DNFCKS101C @ 0xFFF89128; DNFCKS101C->status_register="DNFCSC101STAT"; DNFCKS101C->capture_registers="DNFA41EN";
    noise_clock_status_t DNFCSC101STAT @ 0xFFF8912C;
    noise_clock_t DNFCKS106C @ 0xFFF89130; DNFCKS106C->status_register="DNFCSC106STAT"; DNFCKS106C->capture_registers="DNFA42EN";
    noise_clock_status_t DNFCSC106STAT @ 0xFFF89134;
    noise_clock_t DNFCKS107C @ 0xFFF89138; DNFCKS107C->status_register="DNFCSC107STAT"; DNFCKS107C->capture_registers="DNFA43EN";
    noise_clock_status_t DNFCSC107STAT @ 0xFFF8913C;
    noise_clock_t DNFCKS108C @ 0xFFF89140; DNFCKS108C->status_register="DNFCSC108STAT"; DNFCKS108C->allowed_values="2,4,6"; DNFCKS108C->capture_registers="DNFA5EN,DNFA6EN,DNFA7EN,DNFA8EN,DNFA9EN";
    noise_clock_status_t DNFCSC108STAT @ 0xFFF89144;
    noise_clock_t DNFCKS109C @ 0xFFF89148; DNFCKS109C->status_register="DNFCSC109STAT"; DNFCKS109C->allowed_values="2,4,6"; DNFCKS109C->capture_registers="DNFA10EN,DNFA11EN,DNFA12EN,DNFA13EN,DNFA14EN";
    noise_clock_status_t DNFCSC109STAT @ 0xFFF8914C;
    noise_clock_t DNFCKS110C @ 0xFFF89150; DNFCKS110C->status_register="DNFCSC110STAT"; DNFCKS110C->allowed_values="2,4,6"; DNFCKS110C->capture_registers="DNFA15EN,DNFA16EN,DNFA17EN,DNFA18EN,DNFA19EN";
    noise_clock_status_t DNFCSC110STAT @ 0xFFF89154;
    noise_clock_t DNFCKS112C @ 0xFFF89158; DNFCKS112C->status_register="DNFCSC112STAT"; DNFCKS112C->allowed_values="2,4,6"; DNFCKS112C->capture_registers="DNFA20EN,DNFA21EN,DNFA22EN,DNFA23EN";
    noise_clock_status_t DNFCSC112STAT @ 0xFFF8915C;
    noise_clock_t DNFCKS113C @ 0xFFF89160; DNFCKS113C->status_register="DNFCSC113STAT"; DNFCKS113C->allowed_values="2,4,6"; DNFCKS113C->capture_registers="DNFA24EN,DNFA25EN,DNFA26EN,DNFA27EN";
    noise_clock_status_t DNFCSC113STAT @ 0xFFF89164;
    noise_clock_t DNFCKS114C @ 0xFFF89168; DNFCKS114C->status_register="DNFCSC114STAT"; DNFCKS114C->allowed_values="2,4,6"; DNFCKS114C->capture_registers="DNFA28EN,DNFA29EN,DNFA30EN,DNFA31EN";
    noise_clock_status_t DNFCSC114STAT @ 0xFFF8916C;
    noise_clock_t DNFCKS104C @ 0xFFF89170; DNFCKS104C->status_register="DNFCSC104STAT"; DNFCKS104C->capture_registers="DNFA32EN,DNFA33EN,DNFA34EN,DNFA38EN";
    noise_clock_status_t DNFCSC104STAT @ 0xFFF89174;
    noise_clock_t DNFCKS105C @ 0xFFF89178; DNFCKS105C->status_register="DNFCSC105STAT"; DNFCKS105C->capture_registers="DNFA35EN,DNFA36EN,DNFA37EN,DNFA39EN";
    noise_clock_status_t DNFCSC105STAT @ 0xFFF8917C;
    noise_clock_t DNFCKS102C @ 0xFFF89180; DNFCKS102C->status_register="DNFCSC102STAT"; DNFCKS102C->capture_registers="DNFA40EN";
    noise_clock_status_t DNFCSC102STAT @ 0xFFF89184;

    // CVM configuration is digital state; comparator results and CVMOUT remain
    // explicit external inputs, not synthesized nominal-voltage/diagnostic success.
    reg {
        regwidth=8; accesswidth=8; desc="Latched CVM voltage/CVMOUT factors; POR-only reset, CVMFC clears selected flags";
        evidence="manual"; source_ref="R01UH0585EJ0120 pages445-447 Tables10.2-10.5";
        behavior="cvm"; active_mask=0x83; reset_classes="power-on";
        field { sw=r; hw=w; reset=0; } value[7:0];
    } CVMF @ 0xFFF82C00;
    reg {
        regwidth=8; accesswidth=8; desc="CVM enable configuration reflected from first CVMDEW write after POR; reserved bits1:0 read3";
        evidence="manual"; source_ref="R01UH0585EJ0120 pages445,448-449 Tables10.3,10.6-10.7";
        behavior="cvm"; active_mask=0xBC; reset_classes="power-on";
        field { sw=r; hw=w; reset=3; } value[7:0];
    } CVMDE @ 0xFFF82C04;
    reg {
        regwidth=8; accesswidth=8; desc="CVMOUT mask control; does not itself supply external pin feedback";
        evidence="manual"; source_ref="R01UH0585EJ0120 pages445,450 Tables10.3,10.8";
        behavior="cvm"; writable_mask=1; reset_classes="power-on,system-1-pin";
        field { sw=rw; reset=0; } value[7:0];
    } CVMDMASK @ 0xFFF82C0C;
    reg {
        regwidth=8; accesswidth=8; desc="CVM comparator diagnostic reference selection; no fixed comparator result";
        evidence="manual"; source_ref="R01UH0585EJ0120 pages445,451 Tables10.3,10.9";
        behavior="cvm"; writable_mask=0xC; reset_classes="power-on,system-1-cvm,system-1-pin";
        field { sw=rw; reset=0; } value[7:0];
    } CVMDIAG @ 0xFFF82C10;
    reg {
        regwidth=8; accesswidth=8; desc="CVMOUT pin monitor; level requires explicit external input, not reset-initialized";
        evidence="manual"; source_ref="R01UH0585EJ0120 pages445,452 Tables10.3,10.10";
        behavior="cvm"; active_mask=1;
        field { sw=r; hw=w; } value[7:0];
    } CVMMON @ 0xFFF82C14;
    reg {
        regwidth=8; accesswidth=8; desc="CVM factor write-one clear; always reads zero";
        evidence="manual"; source_ref="R01UH0585EJ0120 page447 Table10.5";
        behavior="cvm"; trigger="cvm-factor-clear"; status_register="CVMF"; writable_mask=0x83; read_value=0;
        field { sw=w; reset=0; } value[7:0];
    } CVMFC @ 0xFFF82C18;
    reg {
        regwidth=8; accesswidth=8; desc="CVM enable one-write latch; only POR rearms, subsequent writes ignored; always reads zero";
        evidence="manual"; source_ref="R01UH0585EJ0120 page449 Table10.7; camry-8965F3307000 CodeFlash0x40E-0x418";
        behavior="cvm"; trigger="cvm-enable-once"; status_register="CVMDE"; writable_mask=0xBC; read_value=0;
        field { sw=w; reset=0; } value[7:0];
    } CVMDEW @ 0xFFF82C1C;

    // Field BIST results are inputs from the reset-time hardware test, not fixed
    // reset constants. Table 31.194's example signatures must not seed these.
    reg {
        regwidth=32; accesswidth=32; desc="Logic BIST reference 1; opaque 20-bit reset-time input";
        evidence="manual"; source_ref="R01UH0585EJ0120 pages2767-2768,2783 Table8.2";
        behavior="bist"; active_mask=0xFFFFF;
        reset_classes="power-on,system-1-cvm,system-1-pin,system-2";
        field { sw=r; } value[31:0];
    } LBISTREF1 @ 0xFFCDA000;
    reg {
        regwidth=32; accesswidth=32; desc="Logic BIST reference 2; opaque 20-bit reset-time input";
        evidence="manual"; source_ref="R01UH0585EJ0120 pages2767,2769,2783 Table8.2";
        behavior="bist"; active_mask=0xFFFFF;
        reset_classes="power-on,system-1-cvm,system-1-pin,system-2";
        field { sw=r; } value[31:0];
    } LBISTREF2 @ 0xFFCDA004;
    reg {
        regwidth=32; accesswidth=32; desc="Memory BIST reference; opaque 20-bit reset-time input";
        evidence="manual"; source_ref="R01UH0585EJ0120 pages2767,2770,2783 Table8.2";
        behavior="bist"; active_mask=0xFFFFF;
        reset_classes="power-on,system-1-cvm,system-1-pin,system-2";
        field { sw=r; } value[31:0];
    } MBISTREF @ 0xFFCDA008;
    reg {
        regwidth=32; accesswidth=32; desc="Logic BIST signature 1; opaque 20-bit reset-time result";
        evidence="manual"; source_ref="R01UH0585EJ0120 pages2767,2771,2783 Table8.2";
        behavior="bist"; active_mask=0xFFFFF;
        reset_classes="power-on,system-1-cvm,system-1-pin,system-2";
        field { sw=r; } value[31:0];
    } LBISTSIG1 @ 0xFFCDA010;
    reg {
        regwidth=32; accesswidth=32; desc="Logic BIST signature 2; opaque 20-bit reset-time result";
        evidence="manual"; source_ref="R01UH0585EJ0120 pages2767,2772,2783 Table8.2";
        behavior="bist"; active_mask=0xFFFFF;
        reset_classes="power-on,system-1-cvm,system-1-pin,system-2";
        field { sw=r; } value[31:0];
    } LBISTSIG2 @ 0xFFCDA014;
    reg {
        regwidth=32; accesswidth=32; desc="Memory BIST signature; opaque 20-bit reset-time result";
        evidence="manual"; source_ref="R01UH0585EJ0120 pages2767,2773,2783 Table8.2";
        behavior="bist"; active_mask=0xFFFFF;
        reset_classes="power-on,system-1-cvm,system-1-pin,system-2";
        field { sw=r; } value[31:0];
    } MBISTSIG @ 0xFFCDA018;
    reg {
        regwidth=32; accesswidth=32; desc="Memory BIST RAM-group results low; explicit reset-time input";
        evidence="manual"; source_ref="R01UH0585EJ0120 pages2774-2775 Table8.2";
        behavior="bist"; active_mask=0xFFFFFFFF; skipped_value=0xFFFFFFFF;
        reset_classes="power-on,system-1-cvm,system-1-pin,system-2";
        field { sw=r; } value[31:0];
    } MBISTFTAGL @ 0xFFCDA020;
    reg {
        regwidth=32; accesswidth=32; desc="Memory BIST RAM-group results high; explicit reset-time input";
        evidence="manual"; source_ref="R01UH0585EJ0120 pages2776-2778 Table8.2";
        behavior="bist"; active_mask=0xFFFFFFFF; skipped_value=0xFFFFFFFF;
        reset_classes="power-on,system-1-cvm,system-1-pin,system-2";
        field { sw=r; } value[31:0];
    } MBISTFTAGH @ 0xFFCDA024;
    reg {
        regwidth=32; accesswidth=32; desc="BIST sequencer result; 2 means normally completed, not a diagnostic reset-cause flag";
        evidence="manual"; source_ref="R01UH0585EJ0120 page2779 Table31.205 Table8.2";
        behavior="bist"; active_mask=3; skipped_value=1;
        reset_classes="power-on,system-1-cvm,system-1-pin,system-2";
        field { sw=r; } value[31:0];
    } BSEQ0ST @ 0xFFCDA030;
    reg {
        regwidth=32; accesswidth=32; desc="Inverted low two bits of BIST sequencer result";
        evidence="manual"; source_ref="R01UH0585EJ0120 page2780 Table31.206 Table8.2";
        behavior="bist"; active_mask=3; skipped_value=2;
        reset_classes="power-on,system-1-cvm,system-1-pin,system-2";
        field { sw=r; } value[31:0];
    } BSEQ0STB @ 0xFFCDA034;
    reg {
        regwidth=32; accesswidth=32; desc="Field BIST failure bits: LBIST1 bit0, LBIST2 bit1, MBIST bit2; skipped=7";
        evidence="manual"; source_ref="R01UH0585EJ0120 page2781 Table31.207 Table8.2";
        behavior="bist"; active_mask=7; skipped_value=7;
        reset_classes="power-on,system-1-cvm,system-1-pin,system-2";
        field { sw=r; } value[31:0];
    } BISTST @ 0xFFCDA038;
    reg {
        regwidth=32; accesswidth=32; desc="Field BIST enable for pin System Reset 1 and System Reset 2; retained otherwise except POR/CVM";
        evidence="manual"; source_ref="R01UH0585EJ0120 page2782 Table31.208 Table8.2";
        behavior="bist"; trigger="bist-control"; active_mask=1;
        reset_classes="power-on,system-1-cvm";
        field { sw=rw; reset=1; } value[31:0];
    } BSEQ0CTL @ 0xFFF80200;

    external mem { memwidth=8; mementries=0x100000; sw=r; evidence="manual"; source_ref="R01UH0585EJ0120 Table 4.1"; executable=true; reset_policy="retained nonvolatile"; } codeflash_user @ 0x00000000;
    external mem { memwidth=8; mementries=0x8000; sw=r; evidence="manual"; source_ref="R01UH0585EJ0120 Table 4.1"; executable=true; reset_policy="retained nonvolatile"; } codeflash_extended @ 0x01000000;
    external mem { memwidth=8; mementries=0x8000; sw=rw; evidence="manual"; source_ref="R01UH0585EJ0120 Table 4.1"; executable=false; reset_policy="retained nonvolatile; FACI writes only"; } dataflash @ 0xFF200000;
    external mem {
        memwidth=8; mementries=0x20000; sw=rw; evidence="manual"; source_ref="R01UH0585EJ0120 Table 4.1";
        executable=true; alias_group="local_ram"; reset_policy="STAC_LM0 by reset class"; reset_control="STAC_LM0";
        reset_rules="power-on:force;system-1-cvm:force;system-1-pin:controlled;system-2:controlled;application-1:controlled";
    } local_ram_pe1 @ 0xFEBE0000;
    external mem { memwidth=8; mementries=0x20000; sw=rw; evidence="manual"; source_ref="R01UH0585EJ0120 Table 4.1"; executable=true; alias_group="local_ram"; reset_policy="STAC_LM0 by reset class"; } local_ram_self @ 0xFEDE0000;
    external mem {
        memwidth=8; mementries=0x10000; sw=rw; evidence="manual"; source_ref="R01UH0585EJ0120 Table 4.1";
        executable=true; reset_policy="STAC_GRAM for Application Reset 1"; reset_control="STAC_GRAM";
        reset_rules="power-on:force;system-1-cvm:force;system-1-pin:force;system-2:force;application-1:controlled";
    } global_ram @ 0xFEEF8000;

    // Protected internal FLMD0 pull selection; this does not model the external pin level.
    reg {
        regwidth=32; accesswidth=32; desc="FLMD0 internal pull selection; protected A5/value/inverse/value sequence";
        evidence="manual"; source_ref="R01UH0585EJ0120 pages2870-2871 Tables35.8-35.9"; behavior="flmd";
        trigger="flmd-control"; status_register="FLMDPS";
        field { sw=rw; reset=0; } value[31:0];
    } FLMDCNT @ 0xFFA00000;

    reg {
        regwidth=32; accesswidth=32; desc="FLMD write-protection command; only complete valid sequences are modeled";
        evidence="manual"; source_ref="R01UH0585EJ0120 pages2871-2873 Table35.10"; behavior="flmd";
        trigger="flmd-command";
        field { sw=w; reset=0; } value[31:0];
    } FLMDPCMD @ 0xFFA00004;

    reg {
        regwidth=32; accesswidth=32; desc="FLMD write-sequence error monitor; bit0 cleared by successful protected update";
        evidence="manual"; source_ref="R01UH0585EJ0120 pages2871,2874 Table35.11"; behavior="flmd";
        field { sw=r; reset=0; } value[31:0];
    } FLMDPS @ 0xFFA00008;

    reg {
        regwidth=32; accesswidth=32;
        desc="Operating-mode pin latch; FLMD0/1 sampled at pin-reset release, FLMD1 reads zero in normal mode";
        evidence="manual"; source_ref="R01UH0585EJ0120 section5.3 Tables5.3-5.5";
        behavior="mode-latch"; active_mask=3; reset_classes="system-1-pin";
        field { sw=r; hw=w; } value[31:0];
    } MODE @ 0xFFF80104;

    reg {
        regwidth=32; accesswidth=32;
        desc="Reset factors: cause-dependent sticky flags; bit6 has undefined read data";
        evidence="manual"; source_ref="R01UH0585EJ0120 section8.3.1 Table8.6";
        behavior="reset-controller"; trigger="reset-factors"; reset_mask=0xFFFFF910;
        field { sw=r; reset=0; } value[31:0];
    } RESF @ 0xFFF81000;

    reg {
        regwidth=32; accesswidth=32;
        desc="Write-one reset-factor clear; only implemented flag bits are effective";
        evidence="manual"; source_ref="R01UH0585EJ0120 section8.3.2 Table8.7";
        behavior="reset-controller"; trigger="reset-factor-clear";
        writable_mask=0x6AF; read_value=0; status_register="RESF";
        field { sw=w; reset=0; } value[31:0];
    } RESFC @ 0xFFF81008;

    // Canonical611FA uses DCRA0 CTL=22: SAEJ1850, low8 input, MSB first.
    reg {
        regwidth=32; accesswidth=32; desc="DCRA0 CRC input; original serial frame CRC8 uses low8 per word write";
        evidence="manual"; source_ref="R01UH0585EJ0120 sections33.2.1,33.3.2-33.4 Tables33.7-33.10"; behavior="dcra";
        trigger="dcra-input"; status_register="DCRA0COUT"; mode_register="DCRA0CTL";
        reset_classes="power-on,system-1-cvm,system-1-pin,system-2,application-1";
        field { sw=rw; reset=0; } value[31:0];
    } DCRA0CIN @ 0xFFD50000;
    reg {
        regwidth=32; accesswidth=32; desc="DCRA0 CRC result; in SAEJ1850 mode low8 read raw XOR FF, high24 undefined";
        evidence="manual"; source_ref="R01UH0585EJ0120 Table33.8,33.10"; behavior="dcra";
        trigger="dcra-seed"; mode_register="DCRA0CTL";
        reset_classes="power-on,system-1-cvm,system-1-pin,system-2,application-1";
        field { sw=rw; reset=0; } value[31:0];
    } DCRA0COUT @ 0xFFD50004;
    reg {
        regwidth=8; accesswidth=8; desc="DCRA0 control; original serial mode22 and reset Ethernet mode00 only";
        evidence="manual"; source_ref="R01UH0585EJ0120 Table33.9"; behavior="dcra";
        trigger="dcra-control";
        reset_classes="power-on,system-1-cvm,system-1-pin,system-2,application-1";
        field { sw=rw; reset=0; } value[7:0];
    } DCRA0CTL @ 0xFFD50020;

    // Exact Camry consumer 00067060 uses only DCRA1, CTL=00 (32-bit Ethernet/32-bit input).
    reg {
        regwidth=32; accesswidth=32; desc="DCRA1 CRC input; 32-bit register accesses only";
        evidence="manual"; source_ref="R01UH0585EJ0120 pages2844,2849 Table33.7"; behavior="dcra";
        trigger="dcra-input"; status_register="DCRA1COUT"; mode_register="DCRA1CTL";
        field { sw=rw; reset=0; } value[31:0];
    } DCRA1CIN @ 0xFFD51000;

    reg {
        regwidth=32; accesswidth=32; desc="DCRA1 CRC data; reads XOR the internal Ethernet CRC state with FFFFFFFF";
        evidence="manual"; source_ref="R01UH0585EJ0120 page2850 Table33.8 and page2852 Table33.10"; behavior="dcra";
        trigger="dcra-seed"; mode_register="DCRA1CTL";
        field { sw=rw; reset=0; } value[31:0];
    } DCRA1COUT @ 0xFFD51004;

    reg {
        regwidth=8; accesswidth=8; desc="DCRA1 control; model supports only POL=00 ISZ=00, other modes fault";
        evidence="manual"; source_ref="R01UH0585EJ0120 page2851 Table33.9"; behavior="dcra";
        trigger="dcra-control";
        field { sw=rw; reset=0; } value[7:0];
    } DCRA1CTL @ 0xFFD51020;
    DCRA1CIN->reset_classes="power-on,system-1-cvm,system-1-pin,system-2,application-1";
    DCRA1COUT->reset_classes="power-on,system-1-cvm,system-1-pin,system-2,application-1";
    DCRA1CTL->reset_classes="power-on,system-1-cvm,system-1-pin,system-2,application-1";

    reg {
        regwidth=32; accesswidth=32; desc="Self-programming ID input word 0";
        evidence="manual"; source_ref="R01UH0615EJ0120 sections 3.3 and 4"; behavior="faci";
        field { sw=w; } value[31:0];
    } SELFID0 @ 0xFFA08000;

    reg {
        regwidth=32; accesswidth=32; desc="Self-programming ID input word 1";
        evidence="manual"; source_ref="R01UH0615EJ0120 sections 3.3 and 4"; behavior="faci";
        field { sw=w; } value[31:0];
    } SELFID1 @ 0xFFA08004;

    reg {
        regwidth=32; accesswidth=32; desc="Self-programming ID input word 2";
        evidence="manual"; source_ref="R01UH0615EJ0120 sections 3.3 and 4"; behavior="faci";
        field { sw=w; } value[31:0];
    } SELFID2 @ 0xFFA08008;

    reg {
        regwidth=32; accesswidth=32; desc="Self-programming ID input word 3";
        evidence="manual"; source_ref="R01UH0615EJ0120 sections 3.3 and 4"; behavior="faci";
        field { sw=w; } value[31:0];
    } SELFID3 @ 0xFFA0800C;

    reg {
        regwidth=8; accesswidth=8; desc="Self-programming ID authentication status";
        evidence="manual"; source_ref="R01UH0615EJ0120 sections 3.3 and 4"; behavior="faci";
        field { sw=r; } value[7:0];
    } SELFIDST @ 0xFFA08010;

    reg {
        regwidth=8; accesswidth=8; desc="Flash pin monitor";
        evidence="manual"; source_ref="R01UH0615EJ0120 sections 3.3 and 4"; behavior="faci";
        field { sw=r; } value[7:0];
    } FPMON @ 0xFFA10000;

    reg {
        regwidth=8; accesswidth=8; desc="Flash access status";
        evidence="manual"; source_ref="R01UH0615EJ0120 pages10-11 Table4.2"; behavior="faci";
        trigger="faci-access-status";
        field { sw=rw; reset=0; } value[7:0];
    } FASTAT @ 0xFFA10010;

    reg {
        regwidth=8; accesswidth=8; desc="Flash access-error interrupt enable";
        evidence="manual"; source_ref="R01UH0615EJ0120 sections 3.3 and 4"; behavior="faci";
        field { sw=rw; } value[7:0];
    } FAEINT @ 0xFFA10014;

    reg {
        regwidth=16; accesswidth=16; desc="CodeFlash memory-area selector";
        evidence="manual"; source_ref="R01UH0615EJ0120 page13 Table4.4"; behavior="faci";
        trigger="faci-area-selector";
        protection_mask=0xff00; protection_value=0x3b00; writable_mask=2;
        field { sw=rw; reset=0; } value[15:0];
    } FAREASELC @ 0xFFA10020;

    reg {
        regwidth=32; accesswidth=32; desc="FACI command start address";
        evidence="manual"; source_ref="R01UH0615EJ0120 page14 Table4.5"; behavior="faci";
        trigger="faci-address"; status_register="FSTATR";
        field { sw=rw; reset=0; } value[31:0];
    } FSADDR @ 0xFFA10030;

    reg {
        regwidth=32; accesswidth=32; desc="FACI command end address";
        evidence="manual"; source_ref="R01UH0615EJ0120 page15 Table4.6"; behavior="faci";
        trigger="faci-address"; status_register="FSTATR";
        field { sw=rw; reset=0; } value[31:0];
    } FEADDR @ 0xFFA10034;

    reg {
        regwidth=32; accesswidth=32; desc="Flash sequencer status";
        evidence="manual"; source_ref="R01UH0615EJ0120 sections 3.3 and 4"; behavior="faci";
        access_widths="1,2,4";
        field { sw=r; reset=0x8000; } value[31:0];
    } FSTATR @ 0xFFA10080;

    reg {
        regwidth=16; accesswidth=16; desc="Flash program-or-erase mode entry";
        evidence="manual"; source_ref="R01UH0615EJ0120 pages21-22 Table4.8"; behavior="faci";
        trigger="faci-dataflash-mode"; status_register="FSTATR";
        field { sw=rw; reset=0; } value[15:0];
    } FENTRYR @ 0xFFA10084;

    reg {
        regwidth=16; accesswidth=16; desc="CodeFlash protection control";
        evidence="manual"; source_ref="R01UH0615EJ0120 page23 Table4.9"; behavior="faci";
        field { sw=rw; reset=0; } value[15:0];
    } FPROTR @ 0xFFA10088;

    reg {
        regwidth=16; accesswidth=16; desc="Flash sequencer setup initialization";
        evidence="manual"; source_ref="R01UH0615EJ0120 page24 Table4.10"; behavior="faci";
        trigger="faci-setup-initialize";
        protection_mask=0xff00; protection_value=0x2d00; writable_mask=1;
        field { sw=rw; reset=0; } value[15:0];
    } FSUINITR @ 0xFFA1008C;

    reg {
        regwidth=8; accesswidth=8; desc="Flash lock-bit status";
        evidence="manual"; source_ref="R01UH0615EJ0120 sections 3.3 and 4"; behavior="faci";
        field { sw=r; } value[7:0];
    } FLKSTAT @ 0xFFA10090;

    reg {
        regwidth=8; accesswidth=8; desc="FACI reset-transfer status";
        evidence="manual"; source_ref="R01UH0615EJ0120 sections 3.3 and 4"; behavior="faci";
        field { sw=r; } value[7:0];
    } FRTSTAT @ 0xFFA10098;

    reg {
        regwidth=8; accesswidth=8; desc="FACI reset-transfer error interrupt enable";
        evidence="manual"; source_ref="R01UH0615EJ0120 sections 3.3 and 4"; behavior="faci";
        field { sw=rw; } value[7:0];
    } FRTEINT @ 0xFFA1009C;

    reg {
        regwidth=16; accesswidth=16; desc="Last FACI command";
        evidence="manual"; source_ref="R01UH0615EJ0120 sections 3.3 and 4"; behavior="faci";
        field { sw=r; reset=0xffff; } value[15:0];
    } FCMDR @ 0xFFA100A0;

    reg {
        regwidth=16; accesswidth=16; desc="Flash program-or-erase status";
        evidence="manual"; source_ref="R01UH0615EJ0120 sections 3.3 and 4"; behavior="faci";
        field { sw=r; } value[15:0];
    } FPESTAT @ 0xFFA100C0;

    reg {
        regwidth=8; accesswidth=8; desc="DataFlash blank-check control";
        evidence="manual"; source_ref="R01UH0615EJ0120 page30 Table4.17"; behavior="faci";
        field { sw=rw; reset=0; } value[7:0];
    } FBCCNT @ 0xFFA100D0;

    reg {
        regwidth=8; accesswidth=8; desc="DataFlash blank-check status";
        evidence="manual"; source_ref="R01UH0615EJ0120 page31 Table4.18"; behavior="faci";
        field { sw=r; reset=0; } value[7:0];
    } FBCSTAT @ 0xFFA100D4;

    reg {
        regwidth=32; accesswidth=32; desc="First programmed DataFlash address";
        evidence="manual"; source_ref="R01UH0615EJ0120 page32 Table4.19"; behavior="faci";
        field { sw=r; reset=0; } value[31:0];
    } FPSADDR @ 0xFFA100D8;

    reg {
        regwidth=16; accesswidth=16; desc="Flash sequencer process switch";
        evidence="manual"; source_ref="R01UH0615EJ0120 page33 Table4.20"; behavior="faci";
        field { sw=rw; reset=0; } value[15:0];
    } FCPSR @ 0xFFA100E0;

    reg {
        regwidth=16; accesswidth=16; desc="Flash sequencer processing-clock notification";
        evidence="manual"; source_ref="R01UH0615EJ0120 page34 Table4.21"; behavior="faci";
        trigger="faci-clock-notify";
        protection_mask=0xff00; protection_value=0x1e00; writable_mask=0xff;
        field { sw=rw; reset=0x28; } value[15:0];
    } FPCKAR @ 0xFFA100E4;

    reg {
        regwidth=8; accesswidth=8; desc="Flash emulation control; only unchanged normal mode is modeled, not OCD-controlled error/timing emulation";
        evidence="manual"; source_ref="R01UH0615EJ0120 page35 Table4.22"; behavior="faci";
        trigger="faci-normal-emulation";
        field { sw=rw; reset=0; } value[7:0];
    } FLEMU @ 0xFFA100F0;

    reg {
        regwidth=16; accesswidth=16; desc="Flash ECC encoder monitor";
        evidence="manual"; source_ref="R01UH0615EJ0120 sections 3.3 and 4"; behavior="faci";
        field { sw=r; } value[15:0];
    } FECCEMON @ 0xFFA10100;

    reg {
        regwidth=16; accesswidth=16; desc="Flash ECC test-mode control";
        evidence="manual"; source_ref="R01UH0615EJ0120 page38 Table4.25"; behavior="faci";
        trigger="ecc-protected-control";
        protection_mask=0xff00; protection_value=0xa600; writable_mask=0x31;
        field { sw=rw; reset=0x30; } value[15:0];
    } FECCTMD @ 0xFFA10104;

    reg {
        regwidth=16; accesswidth=16; desc="Flash dummy ECC value";
        evidence="manual"; source_ref="R01UH0615EJ0120 sections 3.3 and 4"; behavior="faci";
        field { sw=rw; } value[15:0];
    } FDMYECC @ 0xFFA10108;

    reg {
        regwidth=32; accesswidth=8; access_widths="1,2"; desc="FACI command-issuing area: byte commands/count, halfword program data";
        evidence="manual"; source_ref="R01UH0615EJ0120 Table3.1,Tables4.7,4.15,6.2,sections6.3.8-6.3.10,6.3.14-6.3.15"; behavior="faci";
        trigger="faci-command"; status_register="FSTATR"; access_register="FASTAT"; history_register="FCMDR";
        control_register="FENTRYR"; mode_register="FBCCNT"; emulation_register="FLEMU";
        start_address_register="FSADDR"; end_address_register="FEADDR";
        enable_register="FHVE15"; secondary_enable_register="FHVE3";
        field { sw=w; } value[31:0];
    } FACI_COMMAND_AREA @ 0xFFA20000;

    // R01UH0585EJ0120 Table A.1, FACI rows: POR/SR1/SR2 reset,
    // Application Reset 1 retains the sequencer controls and status.
    FASTAT->reset_classes="power-on,system-1-cvm,system-1-pin,system-2";
    FSADDR->reset_classes="power-on,system-1-cvm,system-1-pin,system-2";
    FEADDR->reset_classes="power-on,system-1-cvm,system-1-pin,system-2";
    FSTATR->reset_classes="power-on,system-1-cvm,system-1-pin,system-2";
    FENTRYR->reset_classes="power-on,system-1-cvm,system-1-pin,system-2";
    FSUINITR->reset_classes="power-on,system-1-cvm,system-1-pin,system-2";
    FCMDR->reset_classes="power-on,system-1-cvm,system-1-pin,system-2";
    FBCCNT->reset_classes="power-on,system-1-cvm,system-1-pin,system-2";
    FBCSTAT->reset_classes="power-on,system-1-cvm,system-1-pin,system-2";
    FPSADDR->reset_classes="power-on,system-1-cvm,system-1-pin,system-2";
    FCPSR->reset_classes="power-on,system-1-cvm,system-1-pin,system-2";
    FPCKAR->reset_classes="power-on,system-1-cvm,system-1-pin,system-2";
    FLEMU->reset_classes="power-on,system-1-cvm,system-1-pin,system-2";
    FECCTMD->reset_classes="power-on,system-1-cvm,system-1-pin,system-2";

    reg {
        regwidth=16; accesswidth=16; desc="Boot-flash area selector";
        evidence="manual"; source_ref="R01UH0615EJ0120 sections 3.3 and 4"; behavior="faci";
        field { sw=rw; } value[15:0];
    } BFASELR @ 0xFFC59008;

    reg {
        regwidth=8; accesswidth=8; desc="DataFlash read-cycle code; low4 bits, codes0..2 prohibited; model does not synthesize timing";
        evidence="manual"; source_ref="R01UH0585EJ0120 page2876 Table35.13"; behavior="storage";
        trigger="dataflash-read-cycle";
        field { sw=rw; reset=0xF; } value[7:0];
    } EEPRDCYCL @ 0xFFC59810;

    reg {
        regwidth=32; accesswidth=16; access_widths="2,4"; desc="DataFlash ECC control; PROT[15:14]=01 permits low2-bit update, protection bits read0";
        evidence="manual"; source_ref="R01UH0585EJ0120 page2539 Table31.18"; behavior="storage";
        trigger="ecc-protected-control"; writable_mask=3;
        field { sw=rw; reset=0; } value[31:0];
    } DFECCCTL @ 0xFFC5B000;

    reg {
        regwidth=32; accesswidth=32; desc="DataFlash ECC status: bit0 SEDF and bit1 DEDF; error generation is an explicit external input";
        evidence="manual"; source_ref="R01UH0585EJ0120 page2540 Table31.19"; behavior="storage";
        field { sw=r; reset=0; } value[31:0];
    } DFERSTR @ 0xFFC5B004;

    reg {
        regwidth=32; accesswidth=8; access_widths="1,2,4"; desc="DataFlash ECC status clear: writing low-bit ERRCLR=1 clears SEDF/DEDF; zero has no effect";
        evidence="manual"; source_ref="R01UH0585EJ0120 page2541 Table31.20"; behavior="storage";
        trigger="banked-ecc-clear"; status_register="DFERSTR"; status_masks="3"; writable_mask=1;
        read_input=true;
        field { sw=w; reset=0; } value[31:0];
    } DFERSTC @ 0xFFC5B008;

    reg {
        regwidth=32; accesswidth=8; access_widths="1,2,4"; desc="DataFlash ECC notification enables EOVFIE/DEDIE/SEDIE in low3 bits; ECM delivery not synthesized";
        evidence="manual"; source_ref="R01UH0585EJ0120 page2544 Table31.23"; behavior="storage";
        trigger="ecc-notification"; writable_mask=7;
        field { sw=rw; reset=6; } value[31:0];
    } DFERRINT @ 0xFFC5B014;

    reg {
        regwidth=32; accesswidth=16; access_widths="2,4"; desc="DataFlash ECC test control; PROT[15:14]=01 permits ECCTST bit0 update, protection bits read0";
        evidence="manual"; source_ref="R01UH0585EJ0120 page2546 Table31.25"; behavior="storage";
        trigger="ecc-protected-control"; writable_mask=1;
        field { sw=rw; reset=0; } value[31:0];
    } DFTSTCTL @ 0xFFC5B01C;

    reg {
        regwidth=32; accesswidth=32; desc="ICU-S command register; recovered MAC generate writes (selector<<16)|5 and CMAC verify writes (selector<<16)|7";
        evidence="recovered"; source_ref="Exact target CodeFlash ICU-S driver accesses; public P1M-E manual only identifies ICU-S presence"; behavior="icus_recovered";
        trigger="icus-command"; status_register="ICUSSTS"; secondary_status_register="ICUSSTS2";
        field { sw=rw; } value[31:0];
    } ICUSCMD @ 0xFFC5D000;

    reg {
        regwidth=32; accesswidth=32; desc="ICU-S data/parameter word written beside ICUSCMD (firmware role)";
        evidence="recovered"; source_ref="Exact target CodeFlash ICU-S driver accesses; public P1M-E manual only identifies ICU-S presence"; behavior="icus_recovered";
        field { sw=rw; } value[31:0];
    } ICUSDAT @ 0xFFC5D004;

    reg {
        regwidth=32; accesswidth=32; desc="ICU-S output word consumed by recovered completion callbacks";
        evidence="recovered"; source_ref="Exact target CodeFlash callbacks at 0x0008A514 and 0x0008A58A"; behavior="icus_recovered";
        field { sw=rw; } value[31:0];
    } ICUSOUT @ 0xFFC5D008;

    reg {
        regwidth=32; accesswidth=32; desc="ICU-S status; driver polls bit 0 as busy/ready";
        evidence="recovered"; source_ref="Exact target CodeFlash ICU-S driver accesses; public P1M-E manual only identifies ICU-S presence"; behavior="icus_recovered";
        field { sw=rw; } value[31:0];
    } ICUSSTS @ 0xFFC5D00C;

    reg {
        regwidth=32; accesswidth=32; desc="ICU-S offset10 word; the recovered diagnostic callback encodes set bits in its low twelve bits as errors";
        evidence="recovered"; source_ref="Camry8965F3307000 encode_icus_error_bit_with_bit_nine_fallthrough_8ad7a reads FFC5D010; no hardware reset value inferred"; behavior="icus_recovered";
        field { sw=r; } value[31:0];
    } ICUSREG10 @ 0xFFC5D010;

    reg {
        regwidth=32; accesswidth=32; desc="ICU-S companion status; driver polls low bits with ICUSSTS";
        evidence="recovered"; source_ref="Exact target CodeFlash ICU-S driver accesses; public P1M-E manual only identifies ICU-S presence"; behavior="icus_recovered";
        field { sw=rw; } value[31:0];
    } ICUSSTS2 @ 0xFFC5D014;

    reg {
        regwidth=32; accesswidth=32; desc="ICU-S interrupt/status word read by the recovered service dispatcher";
        evidence="recovered"; source_ref="Exact target CodeFlash dispatcher at 0x0008A4CE"; behavior="icus_recovered";
        field { sw=rw; } value[31:0];
    } ICUSIRQSTS @ 0xFFC5D018;

    reg {
        regwidth=32; accesswidth=32; desc="ICU-S operation parameter written by recovered command setup";
        evidence="recovered"; source_ref="Exact target CodeFlash command setup at 0x0008A63C"; behavior="icus_recovered";
        field { sw=rw; } value[31:0];
    } ICUSPARAM @ 0xFFC5D01C;

    reg {
        regwidth=32; accesswidth=32; desc="ICU-S offset20 word: exact Camry readers consume bit0; model permits observed word reads only, without a hardware reset value or bit meaning";
        evidence="recovered"; source_ref="Camry8965F3307000 792FC reads twice through78AE0;8B018 reads directly. R01UH0585EJ0120 p64 directs Security specification inquiries to the distributor"; behavior="icus_recovered";
        field { sw=r; } value[31:0];
    } ICUSREG20 @ 0xFFC5D020;

    reg {
        regwidth=32; accesswidth=32; desc="ICU-S control/acknowledgement word written by recovered callbacks and reset paths";
        evidence="recovered"; source_ref="Exact target CodeFlash callbacks at 0x0008A538 and 0x0008A5AE; driver reset path"; behavior="icus_recovered";
        trigger="icus-control";
        field { sw=rw; } value[31:0];
    } ICUSCTL @ 0xFFC5D024;

    // Exact target startup self-checks establish these word accesses and
    // expected write/readback storage, not OEM field names or reset values.
    reg icus_test_word_t {
        regwidth=32; accesswidth=32; desc="ICU-S word exercised by the original startup register-pattern self-check";
        evidence="recovered"; source_ref="Camry8965F3307000 reconstructed8A2E4,8A332,8A378; original SST.W/SLD.W at8A2E4"; behavior="icus_recovered";
        field { sw=rw; } value[31:0];
    };
    icus_test_word_t ICUSREG90 @ 0xFFC5D090;
    icus_test_word_t ICUSREG94 @ 0xFFC5D094;
    icus_test_word_t ICUSREG98 @ 0xFFC5D098;
    icus_test_word_t ICUSREG9C @ 0xFFC5D09C;
    icus_test_word_t ICUSREGA0 @ 0xFFC5D0A0;
    icus_test_word_t ICUSREGA4 @ 0xFFC5D0A4;
    icus_test_word_t ICUSREGA8 @ 0xFFC5D0A8;
    icus_test_word_t ICUSREGAC @ 0xFFC5D0AC;
    icus_test_word_t ICUSREGB0 @ 0xFFC5D0B0;
    icus_test_word_t ICUSREGB4 @ 0xFFC5D0B4;
    icus_test_word_t ICUSREGB8 @ 0xFFC5D0B8;
    icus_test_word_t ICUSREGBC @ 0xFFC5D0BC;
    icus_test_word_t ICUSREGE0 @ 0xFFC5D0E0;
    icus_test_word_t ICUSREGF0 @ 0xFFC5D0F0;
    icus_test_word_t ICUSREGF4 @ 0xFFC5D0F4;
    icus_test_word_t ICUSREGF8 @ 0xFFC5D0F8;
    icus_test_word_t ICUSREGFC @ 0xFFC5D0FC;

    reg icus_init_word_t {
        regwidth=32; accesswidth=32; desc="Opaque ICU-S word written during original startup initialization; no additional command or read semantics assigned";
        evidence="recovered"; source_ref="Camry8965F3307000 reconstructed configure_icus_control_and_clear_words_8a4a8"; behavior="icus_recovered";
        field { sw=w; } value[31:0];
    };
    icus_init_word_t ICUSREGC0 @ 0xFFC5D0C0;
    icus_init_word_t ICUSREGE4 @ 0xFFC5D0E4;

    reg {
        regwidth=32; accesswidth=32; access_widths="1,2,4"; desc="Instruction cache data SED clear; bank-select bits 0/1 clear status bits 0/8, overflow bits 0/1 and corresponding captured addresses; reads zero";
        evidence="manual"; source_ref="R01UH0585EJ0120 pages2586,2589 Table31.57,31.60"; behavior="storage";
        trigger="banked-ecc-clear"; writable_mask=3; read_value=0;
        status_register="IDSERSTR_PE1"; secondary_status_register="IDOVFSTR_PE1";
        capture_registers="IDSEDADR0_PE1,IDSEDADR1_PE1"; status_masks="0x1,0x100";
        field { sw=w; reset=0; } value[31:0];
    } IDSERSTCLR_PE1 @ 0xFFC60408;

    reg {
        regwidth=32; accesswidth=32; access_widths="1,2,4"; desc="Instruction cache data DED clear; bank-select bits 0/1 clear status bits 1/9 and corresponding captured addresses; reads zero";
        evidence="manual"; source_ref="R01UH0585EJ0120 pages2586,2590 Table31.57,31.61"; behavior="storage";
        trigger="banked-ecc-clear"; writable_mask=3; read_value=0;
        status_register="IDDERSTR_PE1"; capture_registers="IDDEDADR0_PE1,IDDEDADR1_PE1"; status_masks="0x2,0x200";
        field { sw=w; reset=0; } value[31:0];
    } IDDERSTCLR_PE1 @ 0xFFC6040C;

    reg {
        regwidth=32; accesswidth=32; access_widths="1,2,4"; desc="Instruction cache data SED overflow flags, bank 0/1 in bits 0/1";
        evidence="manual"; source_ref="R01UH0585EJ0120 pages2586,2591 Table31.57,31.62"; behavior="storage";
        field { sw=r; reset=0; } value[31:0];
    } IDOVFSTR_PE1 @ 0xFFC60410;

    reg {
        regwidth=32; accesswidth=32; access_widths="1,2,4"; desc="Instruction cache data SED flags, bank 0/1 in bits 0/8";
        evidence="manual"; source_ref="R01UH0585EJ0120 pages2586,2592 Table31.57,31.63"; behavior="storage";
        field { sw=r; reset=0; } value[31:0];
    } IDSERSTR_PE1 @ 0xFFC60420;

    reg {
        regwidth=32; accesswidth=32; access_widths="1,2,4"; desc="Instruction cache data DED flags, bank 0/1 in bits 1/9";
        evidence="manual"; source_ref="R01UH0585EJ0120 pages2586,2593 Table31.57,31.64"; behavior="storage";
        field { sw=r; reset=0; } value[31:0];
    } IDDERSTR_PE1 @ 0xFFC60450;

    reg {
        regwidth=32; accesswidth=32; desc="Instruction cache data bank 0 SED captured internal address, bits 8:0";
        evidence="manual"; source_ref="R01UH0585EJ0120 pages2586,2594 Table31.57,31.65"; behavior="storage";
        field { sw=r; reset=0; } value[31:0];
    } IDSEDADR0_PE1 @ 0xFFC60460;

    reg {
        regwidth=32; accesswidth=32; desc="Instruction cache data bank 1 SED captured internal address, bits 8:0";
        evidence="manual"; source_ref="R01UH0585EJ0120 pages2586,2594 Table31.57,31.65"; behavior="storage";
        field { sw=r; reset=0; } value[31:0];
    } IDSEDADR1_PE1 @ 0xFFC60464;

    reg {
        regwidth=32; accesswidth=32; desc="Instruction cache data bank 0 DED captured internal address, bits 8:0";
        evidence="manual"; source_ref="R01UH0585EJ0120 pages2586,2595 Table31.57,31.66"; behavior="storage";
        field { sw=r; reset=0; } value[31:0];
    } IDDEDADR0_PE1 @ 0xFFC604E0;

    reg {
        regwidth=32; accesswidth=32; desc="Instruction cache data bank 1 DED captured internal address, bits 8:0";
        evidence="manual"; source_ref="R01UH0585EJ0120 pages2586,2595 Table31.57,31.66"; behavior="storage";
        field { sw=r; reset=0; } value[31:0];
    } IDDEDADR1_PE1 @ 0xFFC604E4;

    reg {
        regwidth=32; accesswidth=32; access_widths="1,2,4"; desc="Instruction cache tag SED clear; bit 0 clears SED status, overflow and captured address; reads zero";
        evidence="manual"; source_ref="R01UH0585EJ0120 pages2586,2598 Table31.57,31.69"; behavior="storage";
        trigger="banked-ecc-clear"; writable_mask=1; read_value=0;
        status_register="ITSERSTR_PE1"; secondary_status_register="ITOVFSTR_PE1";
        capture_registers="ITSEDADR_PE1"; status_masks="0x1";
        field { sw=w; reset=0; } value[31:0];
    } ITSERSTCLR_PE1 @ 0xFFC61408;

    reg {
        regwidth=32; accesswidth=32; access_widths="1,2,4"; desc="Instruction cache tag DED clear; bit 0 clears DED status bit 1 and captured address; reads zero";
        evidence="manual"; source_ref="R01UH0585EJ0120 pages2586,2599 Table31.57,31.70"; behavior="storage";
        trigger="banked-ecc-clear"; writable_mask=1; read_value=0;
        status_register="ITDERSTR_PE1"; capture_registers="ITDEDADR_PE1"; status_masks="0x2";
        field { sw=w; reset=0; } value[31:0];
    } ITDERSTCLR_PE1 @ 0xFFC6140C;

    reg {
        regwidth=32; accesswidth=32; access_widths="1,2,4"; desc="Instruction cache tag SED overflow flag bit 0; reserved bit 4 is undefined after reset";
        evidence="manual"; source_ref="R01UH0585EJ0120 pages2586,2600 Table31.57,31.71"; behavior="storage";
        reset_mask=0xFFFFFFEF;
        field { sw=r; reset=0; } value[31:0];
    } ITOVFSTR_PE1 @ 0xFFC61410;

    reg {
        regwidth=32; accesswidth=32; desc="Instruction cache tag SED status flag bit 0";
        evidence="manual"; source_ref="R01UH0585EJ0120 pages2586,2601 Table31.57,31.72"; behavior="storage";
        field { sw=r; reset=0; } value[31:0];
    } ITSERSTR_PE1 @ 0xFFC61420;

    reg {
        regwidth=32; accesswidth=32; desc="Instruction cache tag DED status flag bit 1";
        evidence="manual"; source_ref="R01UH0585EJ0120 pages2586,2602 Table31.57,31.73"; behavior="storage";
        field { sw=r; reset=0; } value[31:0];
    } ITDERSTR_PE1 @ 0xFFC61450;

    reg {
        regwidth=32; accesswidth=32; desc="Instruction cache tag SED captured address, entry bits 7:0 and way group bit 8";
        evidence="manual"; source_ref="R01UH0585EJ0120 pages2586,2603 Table31.57,31.74"; behavior="storage";
        field { sw=r; reset=0; } value[31:0];
    } ITSEDADR_PE1 @ 0xFFC61460;

    reg {
        regwidth=32; accesswidth=32; desc="Instruction cache tag DED captured address, entry bits 7:0 and way group bit 8";
        evidence="manual"; source_ref="R01UH0585EJ0120 pages2586,2604 Table31.57,31.75"; behavior="storage";
        field { sw=r; reset=0; } value[31:0];
    } ITDEDADR_PE1 @ 0xFFC614E0;

    reg {
        regwidth=32; accesswidth=32; access_widths="1,2,4"; desc="CodeFlash error-report enables: SEDIE0, DEDIE1, APEIE2, SEOVFIE6; ECM delivery not synthesized";
        evidence="manual"; source_ref="R01UH0585EJ0120 Table31.5"; behavior="storage";
        trigger="ecc-notification"; writable_mask=0x47;
        field { sw=rw; reset=0x47; } value[31:0];
    } UCFERRINT @ 0xFFC62000;

    reg {
        regwidth=32; accesswidth=32; access_widths="1,2,4"; desc="CodeFlash ECC single-error status clear; reads always return zero";
        evidence="manual"; source_ref="R01UH0585EJ0120 page2526 Table31.6"; behavior="storage"; read_value=0;
        trigger="banked-ecc-clear"; writable_mask=0xF;
        status_register="UCFSERSTR"; secondary_status_register="UCFOVFSTR";
        capture_registers="UCF1SEDADR,UCF2SEDADR,UCF3SEDADR,UCF4SEDADR";
        status_masks="1,2,4,8"; secondary_status_masks="1,1,1,1";
        field { sw=w; reset=0; } value[31:0];
    } UCFSERSTCLR @ 0xFFC62004;

    reg {
        regwidth=32; accesswidth=32; access_widths="1,2,4"; desc="CodeFlash ECC double-error and address-parity status clear; reads always return zero";
        evidence="manual"; source_ref="R01UH0585EJ0120 page2527 Table31.7"; behavior="storage"; read_value=0;
        trigger="banked-ecc-clear"; writable_mask=1;
        status_register="UCFDERSTR"; capture_registers="UCFDEDADR"; status_masks="0x6";
        field { sw=w; reset=0; } value[31:0];
    } UCFDERSTCLR @ 0xFFC62008;

    reg {
        regwidth=32; accesswidth=32; access_widths="1,2,4"; desc="CodeFlash single-error count overflow status";
        evidence="manual"; source_ref="R01UH0585EJ0120 section 31.2.2"; behavior="storage";
        field { sw=r; reset=0; } value[31:0];
    } UCFOVFSTR @ 0xFFC6200C;

    reg {
        regwidth=32; accesswidth=32; access_widths="1,2,4"; desc="CodeFlash ECC single-error status";
        evidence="manual"; source_ref="R01UH0585EJ0120 section 31.2.2"; behavior="storage";
        field { sw=r; reset=0; } value[31:0];
    } UCFSERSTR @ 0xFFC62020;

    reg {
        regwidth=32; accesswidth=32; access_widths="1,2,4"; desc="CodeFlash ECC double-error and address-parity status";
        evidence="manual"; source_ref="R01UH0585EJ0120 section 31.2.2"; behavior="storage";
        field { sw=r; reset=0; } value[31:0];
    } UCFDERSTR @ 0xFFC62030;

    reg {
        regwidth=32; accesswidth=32; desc="CodeFlash first single-error address";
        evidence="manual"; source_ref="R01UH0585EJ0120 section 31.2.2"; behavior="storage";
        field { sw=r; reset=0; } value[31:0];
    } UCF1SEDADR @ 0xFFC62040;

    reg {
        regwidth=32; accesswidth=32; desc="CodeFlash second single-error address";
        evidence="manual"; source_ref="R01UH0585EJ0120 section 31.2.2"; behavior="storage";
        field { sw=r; reset=0; } value[31:0];
    } UCF2SEDADR @ 0xFFC62044;

    reg {
        regwidth=32; accesswidth=32; desc="CodeFlash third single-error address";
        evidence="manual"; source_ref="R01UH0585EJ0120 section 31.2.2"; behavior="storage";
        field { sw=r; reset=0; } value[31:0];
    } UCF3SEDADR @ 0xFFC62048;

    reg {
        regwidth=32; accesswidth=32; desc="CodeFlash fourth single-error address";
        evidence="manual"; source_ref="R01UH0585EJ0120 section 31.2.2"; behavior="storage";
        field { sw=r; reset=0; } value[31:0];
    } UCF4SEDADR @ 0xFFC6204C;

    reg {
        regwidth=32; accesswidth=32; desc="CodeFlash double-error or address-parity error address";
        evidence="manual"; source_ref="R01UH0585EJ0120 section 31.2.2"; behavior="storage";
        field { sw=r; reset=0; } value[31:0];
    } UCFDEDADR @ 0xFFC620C0;

    reg {
        regwidth=32; accesswidth=16; access_widths="2,4"; desc="CodeFlash address-parity control; PROT[15:14]=01 permits APTESTA/APARIDIS low2-bit update, protection bits read0; no error injection synthesized";
        evidence="manual"; source_ref="R01UH0585EJ0120 page2533 Table31.13"; behavior="storage";
        trigger="ecc-protected-control"; writable_mask=3;
        field { sw=rw; reset=0; } value[31:0];
    } CFAPCTL @ 0xFFC62100;

    reg {
        regwidth=32; accesswidth=16; access_widths="2,4"; desc="CodeFlash ECC control for system-interconnect access; PROT[15:14]=01 permits SECDIS/ECCDIS low2-bit update, protection bits read0";
        evidence="manual"; source_ref="R01UH0585EJ0120 page2534 Table31.14"; behavior="storage";
        trigger="ecc-protected-control"; writable_mask=3;
        field { sw=rw; reset=0; } value[31:0];
    } CFECCCTL_VCI2CFBA @ 0xFFC62200;

    reg {
        regwidth=32; accesswidth=16; access_widths="2,4"; desc="CodeFlash ECC sub-test control for system-interconnect access; keyed ECCTST bit0, key reads zero";
        evidence="manual"; source_ref="R01UH0585EJ0120 Table31.15"; behavior="storage";
        trigger="ecc-protected-control"; writable_mask=1;
        field { sw=rw; reset=0; } value[31:0];
    } CFSTSTCTL_VCI2CFBA @ 0xFFC622F0;

    reg {
        regwidth=32; accesswidth=16; access_widths="2,4"; desc="CodeFlash ECC control for PE1 access; PROT[15:14]=01 permits SECDIS/ECCDIS low2-bit update, protection bits read0";
        evidence="manual"; source_ref="R01UH0585EJ0120 page2534 Table31.14"; behavior="storage";
        trigger="ecc-protected-control"; writable_mask=3;
        field { sw=rw; reset=0; } value[31:0];
    } CFECCCTL_PE1 @ 0xFFC62400;

    reg {
        regwidth=32; accesswidth=16; access_widths="2,4"; desc="CodeFlash ECC sub-test control for PE1 access; keyed ECCTST bit0, key reads zero";
        evidence="manual"; source_ref="R01UH0585EJ0120 Table31.15"; behavior="storage";
        trigger="ecc-protected-control"; writable_mask=1;
        field { sw=rw; reset=0; } value[31:0];
    } CFSTSTCTL_PE1 @ 0xFFC624F0;

    reg {
        regwidth=32; accesswidth=32; access_widths="1,2,4"; desc="ECC error-report enable latches; reserved bits read reset; ECM delivery not synthesized";
        evidence="manual"; source_ref="R01UH0585EJ0120 Tables31.27,31.29"; behavior="storage";
        trigger="ecc-notification";
        writable_mask=0x43;
        field { sw=rw; reset=0x43; } value[31:0];
    } LRERRINT_PE1 @ 0xFFC65404;
    reg {
        regwidth=32; accesswidth=32; access_widths="1,2,4"; desc="Write-one selected error flag/capture clear; zero is a no-op; reads zero";
        evidence="manual"; source_ref="R01UH0585EJ0120 Tables31.27,31.30,31.32,31.33,31.35"; behavior="storage";
        trigger="banked-ecc-clear";
        writable_mask=0xffffffff;
        status_register="LRSERSTR_PE1";
        status_masks="0x1,0x2,0x4,0x8,0x10,0x20,0x40,0x80,0x100,0x200,0x400,0x800,0x1000,0x2000,0x4000,0x8000,0x10000,0x20000,0x40000,0x80000,0x100000,0x200000,0x400000,0x800000,0x1000000,0x2000000,0x4000000,0x8000000,0x10000000,0x20000000,0x40000000,0x80000000";
        read_value=0x0;
        capture_registers="LR1SEDADR0_PE1,LR1SEDADR1_PE1,LR1SEDADR2_PE1,LR1SEDADR3_PE1,LR2SEDADR0_PE1,LR2SEDADR1_PE1,LR2SEDADR2_PE1,LR2SEDADR3_PE1,LR3SEDADR0_PE1,LR3SEDADR1_PE1,LR3SEDADR2_PE1,LR3SEDADR3_PE1,LR4SEDADR0_PE1,LR4SEDADR1_PE1,LR4SEDADR2_PE1,LR4SEDADR3_PE1,LR5SEDADR0_PE1,LR5SEDADR1_PE1,LR5SEDADR2_PE1,LR5SEDADR3_PE1,LR6SEDADR0_PE1,LR6SEDADR1_PE1,LR6SEDADR2_PE1,LR6SEDADR3_PE1,LR7SEDADR0_PE1,LR7SEDADR1_PE1,LR7SEDADR2_PE1,LR7SEDADR3_PE1,LR8SEDADR0_PE1,LR8SEDADR1_PE1,LR8SEDADR2_PE1,LR8SEDADR3_PE1";
        secondary_status_register="LROVFSTR_PE1";
        secondary_status_masks="0x1,0x2,0x4,0x8,0x1,0x2,0x4,0x8,0x1,0x2,0x4,0x8,0x1,0x2,0x4,0x8,0x1,0x2,0x4,0x8,0x1,0x2,0x4,0x8,0x1,0x2,0x4,0x8,0x1,0x2,0x4,0x8";
        field { sw=w; reset=0x0; } value[31:0];
    } LRSERSTCLR_PE1 @ 0xFFC65408;
    reg {
        regwidth=32; accesswidth=32; access_widths="1,2,4"; desc="Write-one selected error flag/capture clear; zero is a no-op; reads zero";
        evidence="manual"; source_ref="R01UH0585EJ0120 Tables31.27,31.31,31.34,31.36"; behavior="storage";
        trigger="banked-ecc-clear";
        writable_mask=0xf;
        status_register="LRDERSTR_PE1";
        status_masks="0x2,0x200,0x20000,0x2000000";
        read_value=0x0;
        capture_registers="LRDEDADR0_PE1,LRDEDADR1_PE1,LRDEDADR2_PE1,LRDEDADR3_PE1";
        field { sw=w; reset=0x0; } value[31:0];
    } LRDERSTCLR_PE1 @ 0xFFC6540C;
    reg {
        regwidth=32; accesswidth=32; access_widths="1,2,4"; desc="Local-RAM ECC error status latch";
        evidence="manual"; source_ref="R01UH0585EJ0120 Tables31.27,31.32-31.34"; behavior="storage";
        field { sw=r; reset=0x0; } value[31:0];
    } LROVFSTR_PE1 @ 0xFFC65410;
    reg {
        regwidth=32; accesswidth=32; access_widths="1,2,4"; desc="Local-RAM ECC error status latch";
        evidence="manual"; source_ref="R01UH0585EJ0120 Tables31.27,31.32-31.34"; behavior="storage";
        field { sw=r; reset=0x0; } value[31:0];
    } LRSERSTR_PE1 @ 0xFFC65440;
    reg {
        regwidth=32; accesswidth=32; access_widths="1,2,4"; desc="Local-RAM ECC error status latch";
        evidence="manual"; source_ref="R01UH0585EJ0120 Tables31.27,31.32-31.34"; behavior="storage";
        field { sw=r; reset=0x0; } value[31:0];
    } LRDERSTR_PE1 @ 0xFFC65450;
    reg {
        regwidth=32; accesswidth=32; desc="Local-RAM single-bit error captured address";
        evidence="manual"; source_ref="R01UH0585EJ0120 Tables31.27,31.35"; behavior="storage";
        field { sw=r; reset=0x0; } value[31:0];
    } LR1SEDADR0_PE1 @ 0xFFC65460;
    reg {
        regwidth=32; accesswidth=32; desc="Local-RAM single-bit error captured address";
        evidence="manual"; source_ref="R01UH0585EJ0120 Tables31.27,31.35"; behavior="storage";
        field { sw=r; reset=0x0; } value[31:0];
    } LR1SEDADR1_PE1 @ 0xFFC65464;
    reg {
        regwidth=32; accesswidth=32; desc="Local-RAM single-bit error captured address";
        evidence="manual"; source_ref="R01UH0585EJ0120 Tables31.27,31.35"; behavior="storage";
        field { sw=r; reset=0x0; } value[31:0];
    } LR1SEDADR2_PE1 @ 0xFFC65468;
    reg {
        regwidth=32; accesswidth=32; desc="Local-RAM single-bit error captured address";
        evidence="manual"; source_ref="R01UH0585EJ0120 Tables31.27,31.35"; behavior="storage";
        field { sw=r; reset=0x0; } value[31:0];
    } LR1SEDADR3_PE1 @ 0xFFC6546C;
    reg {
        regwidth=32; accesswidth=32; desc="Local-RAM single-bit error captured address";
        evidence="manual"; source_ref="R01UH0585EJ0120 Tables31.27,31.35"; behavior="storage";
        field { sw=r; reset=0x0; } value[31:0];
    } LR2SEDADR0_PE1 @ 0xFFC65470;
    reg {
        regwidth=32; accesswidth=32; desc="Local-RAM single-bit error captured address";
        evidence="manual"; source_ref="R01UH0585EJ0120 Tables31.27,31.35"; behavior="storage";
        field { sw=r; reset=0x0; } value[31:0];
    } LR2SEDADR1_PE1 @ 0xFFC65474;
    reg {
        regwidth=32; accesswidth=32; desc="Local-RAM single-bit error captured address";
        evidence="manual"; source_ref="R01UH0585EJ0120 Tables31.27,31.35"; behavior="storage";
        field { sw=r; reset=0x0; } value[31:0];
    } LR2SEDADR2_PE1 @ 0xFFC65478;
    reg {
        regwidth=32; accesswidth=32; desc="Local-RAM single-bit error captured address";
        evidence="manual"; source_ref="R01UH0585EJ0120 Tables31.27,31.35"; behavior="storage";
        field { sw=r; reset=0x0; } value[31:0];
    } LR2SEDADR3_PE1 @ 0xFFC6547C;
    reg {
        regwidth=32; accesswidth=32; desc="Local-RAM single-bit error captured address";
        evidence="manual"; source_ref="R01UH0585EJ0120 Tables31.27,31.35"; behavior="storage";
        field { sw=r; reset=0x0; } value[31:0];
    } LR3SEDADR0_PE1 @ 0xFFC65480;
    reg {
        regwidth=32; accesswidth=32; desc="Local-RAM single-bit error captured address";
        evidence="manual"; source_ref="R01UH0585EJ0120 Tables31.27,31.35"; behavior="storage";
        field { sw=r; reset=0x0; } value[31:0];
    } LR3SEDADR1_PE1 @ 0xFFC65484;
    reg {
        regwidth=32; accesswidth=32; desc="Local-RAM single-bit error captured address";
        evidence="manual"; source_ref="R01UH0585EJ0120 Tables31.27,31.35"; behavior="storage";
        field { sw=r; reset=0x0; } value[31:0];
    } LR3SEDADR2_PE1 @ 0xFFC65488;
    reg {
        regwidth=32; accesswidth=32; desc="Local-RAM single-bit error captured address";
        evidence="manual"; source_ref="R01UH0585EJ0120 Tables31.27,31.35"; behavior="storage";
        field { sw=r; reset=0x0; } value[31:0];
    } LR3SEDADR3_PE1 @ 0xFFC6548C;
    reg {
        regwidth=32; accesswidth=32; desc="Local-RAM single-bit error captured address";
        evidence="manual"; source_ref="R01UH0585EJ0120 Tables31.27,31.35"; behavior="storage";
        field { sw=r; reset=0x0; } value[31:0];
    } LR4SEDADR0_PE1 @ 0xFFC65490;
    reg {
        regwidth=32; accesswidth=32; desc="Local-RAM single-bit error captured address";
        evidence="manual"; source_ref="R01UH0585EJ0120 Tables31.27,31.35"; behavior="storage";
        field { sw=r; reset=0x0; } value[31:0];
    } LR4SEDADR1_PE1 @ 0xFFC65494;
    reg {
        regwidth=32; accesswidth=32; desc="Local-RAM single-bit error captured address";
        evidence="manual"; source_ref="R01UH0585EJ0120 Tables31.27,31.35"; behavior="storage";
        field { sw=r; reset=0x0; } value[31:0];
    } LR4SEDADR2_PE1 @ 0xFFC65498;
    reg {
        regwidth=32; accesswidth=32; desc="Local-RAM single-bit error captured address";
        evidence="manual"; source_ref="R01UH0585EJ0120 Tables31.27,31.35"; behavior="storage";
        field { sw=r; reset=0x0; } value[31:0];
    } LR4SEDADR3_PE1 @ 0xFFC6549C;
    reg {
        regwidth=32; accesswidth=32; desc="Local-RAM single-bit error captured address";
        evidence="manual"; source_ref="R01UH0585EJ0120 Tables31.27,31.35"; behavior="storage";
        field { sw=r; reset=0x0; } value[31:0];
    } LR5SEDADR0_PE1 @ 0xFFC654A0;
    reg {
        regwidth=32; accesswidth=32; desc="Local-RAM single-bit error captured address";
        evidence="manual"; source_ref="R01UH0585EJ0120 Tables31.27,31.35"; behavior="storage";
        field { sw=r; reset=0x0; } value[31:0];
    } LR5SEDADR1_PE1 @ 0xFFC654A4;
    reg {
        regwidth=32; accesswidth=32; desc="Local-RAM single-bit error captured address";
        evidence="manual"; source_ref="R01UH0585EJ0120 Tables31.27,31.35"; behavior="storage";
        field { sw=r; reset=0x0; } value[31:0];
    } LR5SEDADR2_PE1 @ 0xFFC654A8;
    reg {
        regwidth=32; accesswidth=32; desc="Local-RAM single-bit error captured address";
        evidence="manual"; source_ref="R01UH0585EJ0120 Tables31.27,31.35"; behavior="storage";
        field { sw=r; reset=0x0; } value[31:0];
    } LR5SEDADR3_PE1 @ 0xFFC654AC;
    reg {
        regwidth=32; accesswidth=32; desc="Local-RAM single-bit error captured address";
        evidence="manual"; source_ref="R01UH0585EJ0120 Tables31.27,31.35"; behavior="storage";
        field { sw=r; reset=0x0; } value[31:0];
    } LR6SEDADR0_PE1 @ 0xFFC654B0;
    reg {
        regwidth=32; accesswidth=32; desc="Local-RAM single-bit error captured address";
        evidence="manual"; source_ref="R01UH0585EJ0120 Tables31.27,31.35"; behavior="storage";
        field { sw=r; reset=0x0; } value[31:0];
    } LR6SEDADR1_PE1 @ 0xFFC654B4;
    reg {
        regwidth=32; accesswidth=32; desc="Local-RAM single-bit error captured address";
        evidence="manual"; source_ref="R01UH0585EJ0120 Tables31.27,31.35"; behavior="storage";
        field { sw=r; reset=0x0; } value[31:0];
    } LR6SEDADR2_PE1 @ 0xFFC654B8;
    reg {
        regwidth=32; accesswidth=32; desc="Local-RAM single-bit error captured address";
        evidence="manual"; source_ref="R01UH0585EJ0120 Tables31.27,31.35"; behavior="storage";
        field { sw=r; reset=0x0; } value[31:0];
    } LR6SEDADR3_PE1 @ 0xFFC654BC;
    reg {
        regwidth=32; accesswidth=32; desc="Local-RAM single-bit error captured address";
        evidence="manual"; source_ref="R01UH0585EJ0120 Tables31.27,31.35"; behavior="storage";
        field { sw=r; reset=0x0; } value[31:0];
    } LR7SEDADR0_PE1 @ 0xFFC654C0;
    reg {
        regwidth=32; accesswidth=32; desc="Local-RAM single-bit error captured address";
        evidence="manual"; source_ref="R01UH0585EJ0120 Tables31.27,31.35"; behavior="storage";
        field { sw=r; reset=0x0; } value[31:0];
    } LR7SEDADR1_PE1 @ 0xFFC654C4;
    reg {
        regwidth=32; accesswidth=32; desc="Local-RAM single-bit error captured address";
        evidence="manual"; source_ref="R01UH0585EJ0120 Tables31.27,31.35"; behavior="storage";
        field { sw=r; reset=0x0; } value[31:0];
    } LR7SEDADR2_PE1 @ 0xFFC654C8;
    reg {
        regwidth=32; accesswidth=32; desc="Local-RAM single-bit error captured address";
        evidence="manual"; source_ref="R01UH0585EJ0120 Tables31.27,31.35"; behavior="storage";
        field { sw=r; reset=0x0; } value[31:0];
    } LR7SEDADR3_PE1 @ 0xFFC654CC;
    reg {
        regwidth=32; accesswidth=32; desc="Local-RAM single-bit error captured address";
        evidence="manual"; source_ref="R01UH0585EJ0120 Tables31.27,31.35"; behavior="storage";
        field { sw=r; reset=0x0; } value[31:0];
    } LR8SEDADR0_PE1 @ 0xFFC654D0;
    reg {
        regwidth=32; accesswidth=32; desc="Local-RAM single-bit error captured address";
        evidence="manual"; source_ref="R01UH0585EJ0120 Tables31.27,31.35"; behavior="storage";
        field { sw=r; reset=0x0; } value[31:0];
    } LR8SEDADR1_PE1 @ 0xFFC654D4;
    reg {
        regwidth=32; accesswidth=32; desc="Local-RAM single-bit error captured address";
        evidence="manual"; source_ref="R01UH0585EJ0120 Tables31.27,31.35"; behavior="storage";
        field { sw=r; reset=0x0; } value[31:0];
    } LR8SEDADR2_PE1 @ 0xFFC654D8;
    reg {
        regwidth=32; accesswidth=32; desc="Local-RAM single-bit error captured address";
        evidence="manual"; source_ref="R01UH0585EJ0120 Tables31.27,31.35"; behavior="storage";
        field { sw=r; reset=0x0; } value[31:0];
    } LR8SEDADR3_PE1 @ 0xFFC654DC;
    reg {
        regwidth=32; accesswidth=32; desc="Local-RAM double-bit error captured address";
        evidence="manual"; source_ref="R01UH0585EJ0120 Tables31.27,31.36"; behavior="storage";
        field { sw=r; reset=0x0; } value[31:0];
    } LRDEDADR0_PE1 @ 0xFFC654E0;
    reg {
        regwidth=32; accesswidth=32; desc="Local-RAM double-bit error captured address";
        evidence="manual"; source_ref="R01UH0585EJ0120 Tables31.27,31.36"; behavior="storage";
        field { sw=r; reset=0x0; } value[31:0];
    } LRDEDADR1_PE1 @ 0xFFC654E4;
    reg {
        regwidth=32; accesswidth=32; desc="Local-RAM double-bit error captured address";
        evidence="manual"; source_ref="R01UH0585EJ0120 Tables31.27,31.36"; behavior="storage";
        field { sw=r; reset=0x0; } value[31:0];
    } LRDEDADR2_PE1 @ 0xFFC654E8;
    reg {
        regwidth=32; accesswidth=32; desc="Local-RAM double-bit error captured address";
        evidence="manual"; source_ref="R01UH0585EJ0120 Tables31.27,31.36"; behavior="storage";
        field { sw=r; reset=0x0; } value[31:0];
    } LRDEDADR3_PE1 @ 0xFFC654EC;
    reg {
        regwidth=32; accesswidth=32; access_widths="1,2,4"; desc="ECC error-report enable latches; reserved bits read reset; ECM delivery not synthesized";
        evidence="manual"; source_ref="R01UH0585EJ0120 Tables31.41,31.42"; behavior="storage";
        trigger="ecc-notification";
        writable_mask=0x73;
        field { sw=rw; reset=0x73; } value[31:0];
    } UGRERRINT @ 0xFFC64000;
    reg {
        regwidth=32; accesswidth=32; access_widths="1,2,4"; desc="Write-one selected error flag/capture clear; zero is a no-op; reads zero";
        evidence="manual"; source_ref="R01UH0585EJ0120 Tables31.41,31.43,31.45,31.46,31.48"; behavior="storage";
        trigger="banked-ecc-clear";
        writable_mask=0xffffffff;
        status_register="UGRSERSTR";
        status_masks="0x1,0x2,0x4,0x8,0x10,0x20,0x40,0x80,0x100,0x200,0x400,0x800,0x1000,0x2000,0x4000,0x8000,0x10000,0x20000,0x40000,0x80000,0x100000,0x200000,0x400000,0x800000,0x1000000,0x2000000,0x4000000,0x8000000,0x10000000,0x20000000,0x40000000,0x80000000";
        read_value=0x0;
        capture_registers="UGR1SEDADR,UGR2SEDADR,UGR3SEDADR,UGR4SEDADR,UGR5SEDADR,UGR6SEDADR,UGR7SEDADR,UGR8SEDADR,UGR9SEDADR,UGR10SEDADR,UGR11SEDADR,UGR12SEDADR,UGR13SEDADR,UGR14SEDADR,UGR15SEDADR,UGR16SEDADR,UGR17SEDADR,UGR18SEDADR,UGR19SEDADR,UGR20SEDADR,UGR21SEDADR,UGR22SEDADR,UGR23SEDADR,UGR24SEDADR,UGR25SEDADR,UGR26SEDADR,UGR27SEDADR,UGR28SEDADR,UGR29SEDADR,UGR30SEDADR,UGR31SEDADR,UGR32SEDADR";
        secondary_status_register="UGROVFSTR";
        secondary_status_masks="0x1,0x1,0x1,0x1,0x1,0x1,0x1,0x1,0x1,0x1,0x1,0x1,0x1,0x1,0x1,0x1,0x1,0x1,0x1,0x1,0x1,0x1,0x1,0x1,0x1,0x1,0x1,0x1,0x1,0x1,0x1,0x1";
        field { sw=w; reset=0x0; } value[31:0];
    } UGRSERSTCLR @ 0xFFC64004;
    reg {
        regwidth=32; accesswidth=32; access_widths="1,2,4"; desc="Write-one selected error flag/capture clear; zero is a no-op; reads zero";
        evidence="manual"; source_ref="R01UH0585EJ0120 Tables31.41,31.44,31.47,31.49"; behavior="storage";
        trigger="banked-ecc-clear";
        writable_mask=0x1;
        status_register="UGRDERSTR";
        status_masks="0x31";
        read_value=0x0;
        capture_registers="UGR00DEDADR";
        field { sw=w; reset=0x0; } value[31:0];
    } UGRDERSTCLR @ 0xFFC64008;
    reg {
        regwidth=32; accesswidth=32; access_widths="1,2,4"; desc="Global-RAM ECC error status latch";
        evidence="manual"; source_ref="R01UH0585EJ0120 Tables31.41,31.45-31.47"; behavior="storage";
        field { sw=r; reset=0x0; } value[31:0];
    } UGROVFSTR @ 0xFFC6400C;
    reg {
        regwidth=32; accesswidth=32; access_widths="1,2,4"; desc="Global-RAM ECC error status latch";
        evidence="manual"; source_ref="R01UH0585EJ0120 Tables31.41,31.45-31.47"; behavior="storage";
        field { sw=r; reset=0x0; } value[31:0];
    } UGRSERSTR @ 0xFFC64020;
    reg {
        regwidth=32; accesswidth=32; access_widths="1,2,4"; desc="Global-RAM ECC error status latch";
        evidence="manual"; source_ref="R01UH0585EJ0120 Tables31.41,31.45-31.47"; behavior="storage";
        field { sw=r; reset=0x0; } value[31:0];
    } UGRDERSTR @ 0xFFC64030;
    reg {
        regwidth=32; accesswidth=32; desc="Global-RAM single-bit error captured address";
        evidence="manual"; source_ref="R01UH0585EJ0120 Tables31.41,31.48"; behavior="storage";
        field { sw=r; reset=0x0; } value[31:0];
    } UGR1SEDADR @ 0xFFC64040;
    reg {
        regwidth=32; accesswidth=32; desc="Global-RAM single-bit error captured address";
        evidence="manual"; source_ref="R01UH0585EJ0120 Tables31.41,31.48"; behavior="storage";
        field { sw=r; reset=0x0; } value[31:0];
    } UGR2SEDADR @ 0xFFC64044;
    reg {
        regwidth=32; accesswidth=32; desc="Global-RAM single-bit error captured address";
        evidence="manual"; source_ref="R01UH0585EJ0120 Tables31.41,31.48"; behavior="storage";
        field { sw=r; reset=0x0; } value[31:0];
    } UGR3SEDADR @ 0xFFC64048;
    reg {
        regwidth=32; accesswidth=32; desc="Global-RAM single-bit error captured address";
        evidence="manual"; source_ref="R01UH0585EJ0120 Tables31.41,31.48"; behavior="storage";
        field { sw=r; reset=0x0; } value[31:0];
    } UGR4SEDADR @ 0xFFC6404C;
    reg {
        regwidth=32; accesswidth=32; desc="Global-RAM single-bit error captured address";
        evidence="manual"; source_ref="R01UH0585EJ0120 Tables31.41,31.48"; behavior="storage";
        field { sw=r; reset=0x0; } value[31:0];
    } UGR5SEDADR @ 0xFFC64050;
    reg {
        regwidth=32; accesswidth=32; desc="Global-RAM single-bit error captured address";
        evidence="manual"; source_ref="R01UH0585EJ0120 Tables31.41,31.48"; behavior="storage";
        field { sw=r; reset=0x0; } value[31:0];
    } UGR6SEDADR @ 0xFFC64054;
    reg {
        regwidth=32; accesswidth=32; desc="Global-RAM single-bit error captured address";
        evidence="manual"; source_ref="R01UH0585EJ0120 Tables31.41,31.48"; behavior="storage";
        field { sw=r; reset=0x0; } value[31:0];
    } UGR7SEDADR @ 0xFFC64058;
    reg {
        regwidth=32; accesswidth=32; desc="Global-RAM single-bit error captured address";
        evidence="manual"; source_ref="R01UH0585EJ0120 Tables31.41,31.48"; behavior="storage";
        field { sw=r; reset=0x0; } value[31:0];
    } UGR8SEDADR @ 0xFFC6405C;
    reg {
        regwidth=32; accesswidth=32; desc="Global-RAM single-bit error captured address";
        evidence="manual"; source_ref="R01UH0585EJ0120 Tables31.41,31.48"; behavior="storage";
        field { sw=r; reset=0x0; } value[31:0];
    } UGR9SEDADR @ 0xFFC64060;
    reg {
        regwidth=32; accesswidth=32; desc="Global-RAM single-bit error captured address";
        evidence="manual"; source_ref="R01UH0585EJ0120 Tables31.41,31.48"; behavior="storage";
        field { sw=r; reset=0x0; } value[31:0];
    } UGR10SEDADR @ 0xFFC64064;
    reg {
        regwidth=32; accesswidth=32; desc="Global-RAM single-bit error captured address";
        evidence="manual"; source_ref="R01UH0585EJ0120 Tables31.41,31.48"; behavior="storage";
        field { sw=r; reset=0x0; } value[31:0];
    } UGR11SEDADR @ 0xFFC64068;
    reg {
        regwidth=32; accesswidth=32; desc="Global-RAM single-bit error captured address";
        evidence="manual"; source_ref="R01UH0585EJ0120 Tables31.41,31.48"; behavior="storage";
        field { sw=r; reset=0x0; } value[31:0];
    } UGR12SEDADR @ 0xFFC6406C;
    reg {
        regwidth=32; accesswidth=32; desc="Global-RAM single-bit error captured address";
        evidence="manual"; source_ref="R01UH0585EJ0120 Tables31.41,31.48"; behavior="storage";
        field { sw=r; reset=0x0; } value[31:0];
    } UGR13SEDADR @ 0xFFC64070;
    reg {
        regwidth=32; accesswidth=32; desc="Global-RAM single-bit error captured address";
        evidence="manual"; source_ref="R01UH0585EJ0120 Tables31.41,31.48"; behavior="storage";
        field { sw=r; reset=0x0; } value[31:0];
    } UGR14SEDADR @ 0xFFC64074;
    reg {
        regwidth=32; accesswidth=32; desc="Global-RAM single-bit error captured address";
        evidence="manual"; source_ref="R01UH0585EJ0120 Tables31.41,31.48"; behavior="storage";
        field { sw=r; reset=0x0; } value[31:0];
    } UGR15SEDADR @ 0xFFC64078;
    reg {
        regwidth=32; accesswidth=32; desc="Global-RAM single-bit error captured address";
        evidence="manual"; source_ref="R01UH0585EJ0120 Tables31.41,31.48"; behavior="storage";
        field { sw=r; reset=0x0; } value[31:0];
    } UGR16SEDADR @ 0xFFC6407C;
    reg {
        regwidth=32; accesswidth=32; desc="Global-RAM single-bit error captured address";
        evidence="manual"; source_ref="R01UH0585EJ0120 Tables31.41,31.48"; behavior="storage";
        field { sw=r; reset=0x0; } value[31:0];
    } UGR17SEDADR @ 0xFFC64080;
    reg {
        regwidth=32; accesswidth=32; desc="Global-RAM single-bit error captured address";
        evidence="manual"; source_ref="R01UH0585EJ0120 Tables31.41,31.48"; behavior="storage";
        field { sw=r; reset=0x0; } value[31:0];
    } UGR18SEDADR @ 0xFFC64084;
    reg {
        regwidth=32; accesswidth=32; desc="Global-RAM single-bit error captured address";
        evidence="manual"; source_ref="R01UH0585EJ0120 Tables31.41,31.48"; behavior="storage";
        field { sw=r; reset=0x0; } value[31:0];
    } UGR19SEDADR @ 0xFFC64088;
    reg {
        regwidth=32; accesswidth=32; desc="Global-RAM single-bit error captured address";
        evidence="manual"; source_ref="R01UH0585EJ0120 Tables31.41,31.48"; behavior="storage";
        field { sw=r; reset=0x0; } value[31:0];
    } UGR20SEDADR @ 0xFFC6408C;
    reg {
        regwidth=32; accesswidth=32; desc="Global-RAM single-bit error captured address";
        evidence="manual"; source_ref="R01UH0585EJ0120 Tables31.41,31.48"; behavior="storage";
        field { sw=r; reset=0x0; } value[31:0];
    } UGR21SEDADR @ 0xFFC64090;
    reg {
        regwidth=32; accesswidth=32; desc="Global-RAM single-bit error captured address";
        evidence="manual"; source_ref="R01UH0585EJ0120 Tables31.41,31.48"; behavior="storage";
        field { sw=r; reset=0x0; } value[31:0];
    } UGR22SEDADR @ 0xFFC64094;
    reg {
        regwidth=32; accesswidth=32; desc="Global-RAM single-bit error captured address";
        evidence="manual"; source_ref="R01UH0585EJ0120 Tables31.41,31.48"; behavior="storage";
        field { sw=r; reset=0x0; } value[31:0];
    } UGR23SEDADR @ 0xFFC64098;
    reg {
        regwidth=32; accesswidth=32; desc="Global-RAM single-bit error captured address";
        evidence="manual"; source_ref="R01UH0585EJ0120 Tables31.41,31.48"; behavior="storage";
        field { sw=r; reset=0x0; } value[31:0];
    } UGR24SEDADR @ 0xFFC6409C;
    reg {
        regwidth=32; accesswidth=32; desc="Global-RAM single-bit error captured address";
        evidence="manual"; source_ref="R01UH0585EJ0120 Tables31.41,31.48"; behavior="storage";
        field { sw=r; reset=0x0; } value[31:0];
    } UGR25SEDADR @ 0xFFC640A0;
    reg {
        regwidth=32; accesswidth=32; desc="Global-RAM single-bit error captured address";
        evidence="manual"; source_ref="R01UH0585EJ0120 Tables31.41,31.48"; behavior="storage";
        field { sw=r; reset=0x0; } value[31:0];
    } UGR26SEDADR @ 0xFFC640A4;
    reg {
        regwidth=32; accesswidth=32; desc="Global-RAM single-bit error captured address";
        evidence="manual"; source_ref="R01UH0585EJ0120 Tables31.41,31.48"; behavior="storage";
        field { sw=r; reset=0x0; } value[31:0];
    } UGR27SEDADR @ 0xFFC640A8;
    reg {
        regwidth=32; accesswidth=32; desc="Global-RAM single-bit error captured address";
        evidence="manual"; source_ref="R01UH0585EJ0120 Tables31.41,31.48"; behavior="storage";
        field { sw=r; reset=0x0; } value[31:0];
    } UGR28SEDADR @ 0xFFC640AC;
    reg {
        regwidth=32; accesswidth=32; desc="Global-RAM single-bit error captured address";
        evidence="manual"; source_ref="R01UH0585EJ0120 Tables31.41,31.48"; behavior="storage";
        field { sw=r; reset=0x0; } value[31:0];
    } UGR29SEDADR @ 0xFFC640B0;
    reg {
        regwidth=32; accesswidth=32; desc="Global-RAM single-bit error captured address";
        evidence="manual"; source_ref="R01UH0585EJ0120 Tables31.41,31.48"; behavior="storage";
        field { sw=r; reset=0x0; } value[31:0];
    } UGR30SEDADR @ 0xFFC640B4;
    reg {
        regwidth=32; accesswidth=32; desc="Global-RAM single-bit error captured address";
        evidence="manual"; source_ref="R01UH0585EJ0120 Tables31.41,31.48"; behavior="storage";
        field { sw=r; reset=0x0; } value[31:0];
    } UGR31SEDADR @ 0xFFC640B8;
    reg {
        regwidth=32; accesswidth=32; desc="Global-RAM single-bit error captured address";
        evidence="manual"; source_ref="R01UH0585EJ0120 Tables31.41,31.48"; behavior="storage";
        field { sw=r; reset=0x0; } value[31:0];
    } UGR32SEDADR @ 0xFFC640BC;
    reg {
        regwidth=32; accesswidth=32; desc="Global-RAM data DED/address ECC error captured address";
        evidence="manual"; source_ref="R01UH0585EJ0120 Tables31.41,31.49"; behavior="storage";
        field { sw=r; reset=0x0; } value[31:0];
    } UGR00DEDADR @ 0xFFC640C0;
    reg {
        regwidth=32; accesswidth=32; access_widths="1,2,4"; desc="ECC error-report enable latches; reserved bits read reset; ECM delivery not synthesized";
        evidence="manual"; source_ref="R01UH0585EJ0120 Tables31.89,31.91-31.95"; behavior="storage";
        trigger="ecc-notification";
        writable_mask=0x30;
        field { sw=rw; reset=0x30; } value[31:0];
    } CFERRINT_VCI2CFBB @ 0xFFC62C04;
    reg {
        regwidth=32; accesswidth=32; access_widths="1,2,4"; desc="Write-one selected error flag/capture clear; zero is a no-op; reads zero";
        evidence="manual"; source_ref="R01UH0585EJ0120 Tables31.89,31.91-31.95"; behavior="storage";
        trigger="banked-ecc-clear";
        writable_mask=0x1;
        status_register="CFERSTR_VCI2CFBB";
        status_masks="0xc0";
        read_value=0x0;
        capture_registers="CFEADR0_VCI2CFBB";
        secondary_status_register="CFOVFSTR_VCI2CFBB";
        secondary_status_masks="0x1";
        field { sw=w; reset=0x0; } value[31:0];
    } CFERSTCLR_VCI2CFBB @ 0xFFC62C08;
    reg {
        regwidth=32; accesswidth=32; access_widths="1,2,4"; desc="ECC error capture overflow latch; bit0 ERROVF";
        evidence="manual"; source_ref="R01UH0585EJ0120 Tables31.89,31.91-31.95"; behavior="storage";
        field { sw=r; reset=0x0; } value[31:0];
    } CFOVFSTR_VCI2CFBB @ 0xFFC62C0C;
    reg {
        regwidth=32; accesswidth=32; access_widths="1,2,4"; desc="ECC error status latches; only documented flag bits are cleared";
        evidence="manual"; source_ref="R01UH0585EJ0120 Tables31.89,31.91-31.95"; behavior="storage";
        field { sw=r; reset=0x0; } value[31:0];
    } CFERSTR_VCI2CFBB @ 0xFFC62C10;
    reg {
        regwidth=32; accesswidth=32; desc="ECC error captured address";
        evidence="manual"; source_ref="R01UH0585EJ0120 Tables31.89,31.91-31.95"; behavior="storage";
        field { sw=r; reset=0x0; } value[31:0];
    } CFEADR0_VCI2CFBB @ 0xFFC62C50;
    reg {
        regwidth=32; accesswidth=32; access_widths="1,2,4"; desc="ECC error-report enable latches; reserved bits read reset; ECM delivery not synthesized";
        evidence="manual"; source_ref="R01UH0585EJ0120 Tables31.89,31.97-31.101"; behavior="storage";
        trigger="ecc-notification";
        writable_mask=0x3;
        field { sw=rw; reset=0x3; } value[31:0];
    } IFERRINT_PE1 @ 0xFFC63404;
    reg {
        regwidth=32; accesswidth=32; access_widths="1,2,4"; desc="Write-one selected error flag/capture clear; zero is a no-op; reads zero";
        evidence="manual"; source_ref="R01UH0585EJ0120 Tables31.89,31.97-31.101"; behavior="storage";
        trigger="banked-ecc-clear";
        writable_mask=0x1;
        status_register="IFERSTR_PE1";
        status_masks="0x3";
        read_value=0x0;
        capture_registers="IFERADR_PE1";
        secondary_status_register="IFOVFSTR_PE1";
        secondary_status_masks="0x1";
        field { sw=w; reset=0x0; } value[31:0];
    } IFERSTCLR_PE1 @ 0xFFC63408;
    reg {
        regwidth=32; accesswidth=32; access_widths="1,2,4"; desc="ECC error capture overflow latch; bit0 ERROVF";
        evidence="manual"; source_ref="R01UH0585EJ0120 Tables31.89,31.97-31.101"; behavior="storage";
        field { sw=r; reset=0x0; } value[31:0];
    } IFOVFSTR_PE1 @ 0xFFC6340C;
    reg {
        regwidth=32; accesswidth=32; access_widths="1,2,4"; desc="ECC error status latches; only documented flag bits are cleared";
        evidence="manual"; source_ref="R01UH0585EJ0120 Tables31.89,31.97-31.101"; behavior="storage";
        field { sw=r; reset=0x0; } value[31:0];
    } IFERSTR_PE1 @ 0xFFC63410;
    reg {
        regwidth=32; accesswidth=32; desc="ECC error captured address";
        evidence="manual"; source_ref="R01UH0585EJ0120 Tables31.89,31.97-31.101"; behavior="storage";
        field { sw=r; reset=0x0; } value[31:0];
    } IFERADR_PE1 @ 0xFFC63450;
    reg {
        regwidth=32; accesswidth=32; access_widths="1,2,4"; desc="ECC error-report enable latches; reserved bits read reset; ECM delivery not synthesized";
        evidence="manual"; source_ref="R01UH0585EJ0120 Tables31.89,31.103-31.107"; behavior="storage";
        trigger="ecc-notification";
        writable_mask=0x33;
        field { sw=rw; reset=0x33; } value[31:0];
    } LSSERRINT_PE1 @ 0xFFC66004;
    reg {
        regwidth=32; accesswidth=32; access_widths="1,2,4"; desc="Write-one selected error flag/capture clear; zero is a no-op; reads zero";
        evidence="manual"; source_ref="R01UH0585EJ0120 Tables31.89,31.103-31.107"; behavior="storage";
        trigger="banked-ecc-clear";
        writable_mask=0x1;
        status_register="LSSERSTR_PE1";
        status_masks="0xc3";
        read_value=0x0;
        capture_registers="LSSEADR_PE1";
        secondary_status_register="LSSOVFSTR_PE1";
        secondary_status_masks="0x1";
        field { sw=w; reset=0x0; } value[31:0];
    } LSSERSTCLR_PE1 @ 0xFFC66008;
    reg {
        regwidth=32; accesswidth=32; access_widths="1,2,4"; desc="ECC error capture overflow latch; bit0 ERROVF";
        evidence="manual"; source_ref="R01UH0585EJ0120 Tables31.89,31.103-31.107"; behavior="storage";
        field { sw=r; reset=0x0; } value[31:0];
    } LSSOVFSTR_PE1 @ 0xFFC6600C;
    reg {
        regwidth=32; accesswidth=32; access_widths="1,2,4"; desc="ECC error status latches; only documented flag bits are cleared";
        evidence="manual"; source_ref="R01UH0585EJ0120 Tables31.89,31.103-31.107"; behavior="storage";
        field { sw=r; reset=0x0; } value[31:0];
    } LSSERSTR_PE1 @ 0xFFC66010;
    reg {
        regwidth=32; accesswidth=32; desc="ECC error captured address";
        evidence="manual"; source_ref="R01UH0585EJ0120 Tables31.89,31.103-31.107"; behavior="storage";
        field { sw=r; reset=0x0; } value[31:0];
    } LSSEADR_PE1 @ 0xFFC66050;
    reg {
        regwidth=32; accesswidth=32; access_widths="1,2,4"; desc="ECC error-report enable latches; reserved bits read reset; ECM delivery not synthesized";
        evidence="manual"; source_ref="R01UH0585EJ0120 Tables31.89,31.109-31.113"; behavior="storage";
        trigger="ecc-notification";
        writable_mask=0x3;
        field { sw=rw; reset=0x3; } value[31:0];
    } LSMERRINT_PE1 @ 0xFFC66404;
    reg {
        regwidth=32; accesswidth=32; access_widths="1,2,4"; desc="Write-one selected error flag/capture clear; zero is a no-op; reads zero";
        evidence="manual"; source_ref="R01UH0585EJ0120 Tables31.89,31.109-31.113"; behavior="storage";
        trigger="banked-ecc-clear";
        writable_mask=0x1;
        status_register="LSMERSTR_PE1";
        status_masks="0x3";
        read_value=0x0;
        capture_registers="LSMEADR_PE1";
        secondary_status_register="LSMOVFSTR_PE1";
        secondary_status_masks="0x1";
        field { sw=w; reset=0x0; } value[31:0];
    } LSMERSTCLR_PE1 @ 0xFFC66408;
    reg {
        regwidth=32; accesswidth=32; access_widths="1,2,4"; desc="ECC error capture overflow latch; bit0 ERROVF";
        evidence="manual"; source_ref="R01UH0585EJ0120 Tables31.89,31.109-31.113"; behavior="storage";
        field { sw=r; reset=0x0; } value[31:0];
    } LSMOVFSTR_PE1 @ 0xFFC6640C;
    reg {
        regwidth=32; accesswidth=32; access_widths="1,2,4"; desc="ECC error status latches; only documented flag bits are cleared";
        evidence="manual"; source_ref="R01UH0585EJ0120 Tables31.89,31.109-31.113"; behavior="storage";
        field { sw=r; reset=0x0; } value[31:0];
    } LSMERSTR_PE1 @ 0xFFC66410;
    reg {
        regwidth=32; accesswidth=32; desc="ECC error captured address";
        evidence="manual"; source_ref="R01UH0585EJ0120 Tables31.89,31.109-31.113"; behavior="storage";
        field { sw=r; reset=0x0; } value[31:0];
    } LSMEADR_PE1 @ 0xFFC66450;
    reg {
        regwidth=32; accesswidth=32; access_widths="1,2,4"; desc="ECC error-report enable latches; reserved bits read reset; ECM delivery not synthesized";
        evidence="manual"; source_ref="R01UH0585EJ0120 Tables31.89,31.114-31.118"; behavior="storage";
        trigger="ecc-notification";
        writable_mask=0x3;
        field { sw=rw; reset=0x3; } value[31:0];
    } VPERRINT_SG0 @ 0xFFC67004;
    reg {
        regwidth=32; accesswidth=32; access_widths="1,2,4"; desc="Write-one selected error flag/capture clear; zero is a no-op; reads zero";
        evidence="manual"; source_ref="R01UH0585EJ0120 Tables31.89,31.114-31.118"; behavior="storage";
        trigger="banked-ecc-clear";
        writable_mask=0x1;
        status_register="VPERSTR_SG0";
        status_masks="0x3";
        read_value=0x0;
        capture_registers="VPEADR_SG0";
        secondary_status_register="VPOVFSTR_SG0";
        secondary_status_masks="0x1";
        field { sw=w; reset=0x0; } value[31:0];
    } VPERSTCLR_SG0 @ 0xFFC67008;
    reg {
        regwidth=32; accesswidth=32; access_widths="1,2,4"; desc="ECC error capture overflow latch; bit0 ERROVF";
        evidence="manual"; source_ref="R01UH0585EJ0120 Tables31.89,31.114-31.118"; behavior="storage";
        field { sw=r; reset=0x0; } value[31:0];
    } VPOVFSTR_SG0 @ 0xFFC6700C;
    reg {
        regwidth=32; accesswidth=32; access_widths="1,2,4"; desc="ECC error status latches; only documented flag bits are cleared";
        evidence="manual"; source_ref="R01UH0585EJ0120 Tables31.89,31.114-31.118"; behavior="storage";
        field { sw=r; reset=0x0; } value[31:0];
    } VPERSTR_SG0 @ 0xFFC67010;
    reg {
        regwidth=32; accesswidth=32; desc="ECC error captured address";
        evidence="manual"; source_ref="R01UH0585EJ0120 Tables31.89,31.114-31.118"; behavior="storage";
        field { sw=r; reset=0x0; } value[31:0];
    } VPEADR_SG0 @ 0xFFC67050;
    reg {
        regwidth=32; accesswidth=32; access_widths="1,2,4"; desc="ECC error-report enable latches; reserved bits read reset; ECM delivery not synthesized";
        evidence="manual"; source_ref="R01UH0585EJ0120 Tables31.89,31.114-31.118"; behavior="storage";
        trigger="ecc-notification";
        writable_mask=0x3;
        field { sw=rw; reset=0x3; } value[31:0];
    } VPERRINT_SG1 @ 0xFFC67404;
    reg {
        regwidth=32; accesswidth=32; access_widths="1,2,4"; desc="Write-one selected error flag/capture clear; zero is a no-op; reads zero";
        evidence="manual"; source_ref="R01UH0585EJ0120 Tables31.89,31.114-31.118"; behavior="storage";
        trigger="banked-ecc-clear";
        writable_mask=0x1;
        status_register="VPERSTR_SG1";
        status_masks="0x3";
        read_value=0x0;
        capture_registers="VPEADR_SG1";
        secondary_status_register="VPOVFSTR_SG1";
        secondary_status_masks="0x1";
        field { sw=w; reset=0x0; } value[31:0];
    } VPERSTCLR_SG1 @ 0xFFC67408;
    reg {
        regwidth=32; accesswidth=32; access_widths="1,2,4"; desc="ECC error capture overflow latch; bit0 ERROVF";
        evidence="manual"; source_ref="R01UH0585EJ0120 Tables31.89,31.114-31.118"; behavior="storage";
        field { sw=r; reset=0x0; } value[31:0];
    } VPOVFSTR_SG1 @ 0xFFC6740C;
    reg {
        regwidth=32; accesswidth=32; access_widths="1,2,4"; desc="ECC error status latches; only documented flag bits are cleared";
        evidence="manual"; source_ref="R01UH0585EJ0120 Tables31.89,31.114-31.118"; behavior="storage";
        field { sw=r; reset=0x0; } value[31:0];
    } VPERSTR_SG1 @ 0xFFC67410;
    reg {
        regwidth=32; accesswidth=32; desc="ECC error captured address";
        evidence="manual"; source_ref="R01UH0585EJ0120 Tables31.89,31.114-31.118"; behavior="storage";
        field { sw=r; reset=0x0; } value[31:0];
    } VPEADR_SG1 @ 0xFFC67450;
    reg {
        regwidth=32; accesswidth=32; access_widths="1,2,4"; desc="ECC error-report enable latches; reserved bits read reset; ECM delivery not synthesized";
        evidence="manual"; source_ref="R01UH0585EJ0120 Tables31.89,31.114-31.118"; behavior="storage";
        trigger="ecc-notification";
        writable_mask=0x3;
        field { sw=rw; reset=0x3; } value[31:0];
    } VPERRINT_SG2 @ 0xFFC67804;
    reg {
        regwidth=32; accesswidth=32; access_widths="1,2,4"; desc="Write-one selected error flag/capture clear; zero is a no-op; reads zero";
        evidence="manual"; source_ref="R01UH0585EJ0120 Tables31.89,31.114-31.118"; behavior="storage";
        trigger="banked-ecc-clear";
        writable_mask=0x1;
        status_register="VPERSTR_SG2";
        status_masks="0x3";
        read_value=0x0;
        capture_registers="VPEADR_SG2";
        secondary_status_register="VPOVFSTR_SG2";
        secondary_status_masks="0x1";
        field { sw=w; reset=0x0; } value[31:0];
    } VPERSTCLR_SG2 @ 0xFFC67808;
    reg {
        regwidth=32; accesswidth=32; access_widths="1,2,4"; desc="ECC error capture overflow latch; bit0 ERROVF";
        evidence="manual"; source_ref="R01UH0585EJ0120 Tables31.89,31.114-31.118"; behavior="storage";
        field { sw=r; reset=0x0; } value[31:0];
    } VPOVFSTR_SG2 @ 0xFFC6780C;
    reg {
        regwidth=32; accesswidth=32; access_widths="1,2,4"; desc="ECC error status latches; only documented flag bits are cleared";
        evidence="manual"; source_ref="R01UH0585EJ0120 Tables31.89,31.114-31.118"; behavior="storage";
        field { sw=r; reset=0x0; } value[31:0];
    } VPERSTR_SG2 @ 0xFFC67810;
    reg {
        regwidth=32; accesswidth=32; desc="ECC error captured address";
        evidence="manual"; source_ref="R01UH0585EJ0120 Tables31.89,31.114-31.118"; behavior="storage";
        field { sw=r; reset=0x0; } value[31:0];
    } VPEADR_SG2 @ 0xFFC67850;
    reg {
        regwidth=32; accesswidth=32; access_widths="1,2,4"; desc="ECC error-report enable latches; reserved bits read reset; ECM delivery not synthesized";
        evidence="manual"; source_ref="R01UH0585EJ0120 Tables31.89,31.114-31.118"; behavior="storage";
        trigger="ecc-notification";
        writable_mask=0x3;
        field { sw=rw; reset=0x3; } value[31:0];
    } VPERRINT_SG5 @ 0xFFC68404;
    reg {
        regwidth=32; accesswidth=32; access_widths="1,2,4"; desc="Write-one selected error flag/capture clear; zero is a no-op; reads zero";
        evidence="manual"; source_ref="R01UH0585EJ0120 Tables31.89,31.114-31.118"; behavior="storage";
        trigger="banked-ecc-clear";
        writable_mask=0x1;
        status_register="VPERSTR_SG5";
        status_masks="0x3";
        read_value=0x0;
        capture_registers="VPEADR_SG5";
        secondary_status_register="VPOVFSTR_SG5";
        secondary_status_masks="0x1";
        field { sw=w; reset=0x0; } value[31:0];
    } VPERSTCLR_SG5 @ 0xFFC68408;
    reg {
        regwidth=32; accesswidth=32; access_widths="1,2,4"; desc="ECC error capture overflow latch; bit0 ERROVF";
        evidence="manual"; source_ref="R01UH0585EJ0120 Tables31.89,31.114-31.118"; behavior="storage";
        field { sw=r; reset=0x0; } value[31:0];
    } VPOVFSTR_SG5 @ 0xFFC6840C;
    reg {
        regwidth=32; accesswidth=32; access_widths="1,2,4"; desc="ECC error status latches; only documented flag bits are cleared";
        evidence="manual"; source_ref="R01UH0585EJ0120 Tables31.89,31.114-31.118"; behavior="storage";
        field { sw=r; reset=0x0; } value[31:0];
    } VPERSTR_SG5 @ 0xFFC68410;
    reg {
        regwidth=32; accesswidth=32; desc="ECC error captured address";
        evidence="manual"; source_ref="R01UH0585EJ0120 Tables31.89,31.114-31.118"; behavior="storage";
        field { sw=r; reset=0x0; } value[31:0];
    } VPEADR_SG5 @ 0xFFC68450;
    reg {
        regwidth=32; accesswidth=32; access_widths="1,2,4"; desc="ECC error-report enable latches; reserved bits read reset; ECM delivery not synthesized";
        evidence="manual"; source_ref="R01UH0585EJ0120 Tables31.89,31.120-31.124"; behavior="storage";
        trigger="ecc-notification";
        writable_mask=0x3;
        field { sw=rw; reset=0x3; } value[31:0];
    } VCERRINT_PDMA @ 0xFFC6A004;
    reg {
        regwidth=32; accesswidth=32; access_widths="1,2,4"; desc="Write-one selected error flag/capture clear; zero is a no-op; reads zero";
        evidence="manual"; source_ref="R01UH0585EJ0120 Tables31.89,31.120-31.124"; behavior="storage";
        trigger="banked-ecc-clear";
        writable_mask=0x1;
        status_register="VCERSTR_PDMA";
        status_masks="0x3";
        read_value=0x0;
        capture_registers="VCEADR_PDMA";
        secondary_status_register="VCOVFSTR_PDMA";
        secondary_status_masks="0x1";
        field { sw=w; reset=0x0; } value[31:0];
    } VCERSTCLR_PDMA @ 0xFFC6A008;
    reg {
        regwidth=32; accesswidth=32; access_widths="1,2,4"; desc="ECC error capture overflow latch; bit0 ERROVF";
        evidence="manual"; source_ref="R01UH0585EJ0120 Tables31.89,31.120-31.124"; behavior="storage";
        field { sw=r; reset=0x0; } value[31:0];
    } VCOVFSTR_PDMA @ 0xFFC6A00C;
    reg {
        regwidth=32; accesswidth=32; access_widths="1,2,4"; desc="ECC error status latches; only documented flag bits are cleared";
        evidence="manual"; source_ref="R01UH0585EJ0120 Tables31.89,31.120-31.124"; behavior="storage";
        field { sw=r; reset=0x0; } value[31:0];
    } VCERSTR_PDMA @ 0xFFC6A010;
    reg {
        regwidth=32; accesswidth=32; desc="ECC error captured address";
        evidence="manual"; source_ref="R01UH0585EJ0120 Tables31.89,31.120-31.124"; behavior="storage";
        field { sw=r; reset=0x0; } value[31:0];
    } VCEADR_PDMA @ 0xFFC6A050;
    reg {
        regwidth=32; accesswidth=32; access_widths="1,2,4"; desc="ECC error-report enable latches; reserved bits read reset; ECM delivery not synthesized";
        evidence="manual"; source_ref="R01UH0585EJ0120 Tables31.89,31.126-31.130"; behavior="storage";
        trigger="ecc-notification";
        writable_mask=0x73;
        field { sw=rw; reset=0x73; } value[31:0];
    } APERRINT_PFSS @ 0xFFC6C004;
    reg {
        regwidth=32; accesswidth=32; access_widths="1,2,4"; desc="Write-one selected error flag/capture clear; zero is a no-op; reads zero";
        evidence="manual"; source_ref="R01UH0585EJ0120 Tables31.89,31.126-31.130"; behavior="storage";
        trigger="banked-ecc-clear";
        writable_mask=0x1;
        status_register="APERSTR_PFSS";
        status_masks="0xc3";
        read_value=0x0;
        capture_registers="APEADR_PFSS";
        secondary_status_register="APOVFSTR_PFSS";
        secondary_status_masks="0x1";
        field { sw=w; reset=0x0; } value[31:0];
    } APERSTCLR_PFSS @ 0xFFC6C008;
    reg {
        regwidth=32; accesswidth=32; access_widths="1,2,4"; desc="ECC error capture overflow latch; bit0 ERROVF";
        evidence="manual"; source_ref="R01UH0585EJ0120 Tables31.89,31.126-31.130"; behavior="storage";
        field { sw=r; reset=0x0; } value[31:0];
    } APOVFSTR_PFSS @ 0xFFC6C00C;
    reg {
        regwidth=32; accesswidth=32; access_widths="1,2,4"; desc="ECC error status latches; only documented flag bits are cleared";
        evidence="manual"; source_ref="R01UH0585EJ0120 Tables31.89,31.126-31.130"; behavior="storage";
        field { sw=r; reset=0x0; } value[31:0];
    } APERSTR_PFSS @ 0xFFC6C010;
    reg {
        regwidth=32; accesswidth=32; desc="ECC error captured address";
        evidence="manual"; source_ref="R01UH0585EJ0120 Tables31.89,31.126-31.130"; behavior="storage";
        field { sw=r; reset=0x0; } value[31:0];
    } APEADR_PFSS @ 0xFFC6C050;
    reg {
        regwidth=32; accesswidth=32; access_widths="1,2,4"; desc="ECC error-report enable latches; reserved bits read reset; ECM delivery not synthesized";
        evidence="manual"; source_ref="R01UH0585EJ0120 Tables31.89,31.133-31.137"; behavior="storage";
        trigger="ecc-notification";
        writable_mask=0x73;
        field { sw=rw; reset=0x73; } value[31:0];
    } APEC0ERRINT @ 0xFFDDD804;
    reg {
        regwidth=32; accesswidth=32; access_widths="1,2,4"; desc="Write-one selected error flag/capture clear; zero is a no-op; reads zero";
        evidence="manual"; source_ref="R01UH0585EJ0120 Tables31.89,31.133-31.137"; behavior="storage";
        trigger="banked-ecc-clear";
        writable_mask=0x1;
        status_register="APEC01STERSTR";
        status_masks="0xc3";
        read_value=0x0;
        capture_registers="APEC01STEADR0";
        secondary_status_register="APEC0OVFSTR";
        secondary_status_masks="0x1";
        field { sw=w; reset=0x0; } value[31:0];
    } APEC0STCLR @ 0xFFDDD808;
    reg {
        regwidth=32; accesswidth=32; access_widths="1,2,4"; desc="ECC error capture overflow latch; bit0 ERROVF";
        evidence="manual"; source_ref="R01UH0585EJ0120 Tables31.89,31.133-31.137"; behavior="storage";
        field { sw=r; reset=0x0; } value[31:0];
    } APEC0OVFSTR @ 0xFFDDD80C;
    reg {
        regwidth=32; accesswidth=32; access_widths="1,2,4"; desc="ECC error status latches; only documented flag bits are cleared";
        evidence="manual"; source_ref="R01UH0585EJ0120 Tables31.89,31.133-31.137"; behavior="storage";
        field { sw=r; reset=0x0; } value[31:0];
    } APEC01STERSTR @ 0xFFDDD810;
    reg {
        regwidth=32; accesswidth=32; desc="ECC error captured address";
        evidence="manual"; source_ref="R01UH0585EJ0120 Tables31.89,31.133-31.137"; behavior="storage";
        field { sw=r; reset=0x0; } value[31:0];
    } APEC01STEADR0 @ 0xFFDDD850;
    reg {
        regwidth=32; accesswidth=32; access_widths="1,2,4"; desc="ECC error-report enable latches; reserved bits read reset; ECM delivery not synthesized";
        evidence="manual"; source_ref="R01UH0585EJ0120 Tables31.89,31.133-31.137"; behavior="storage";
        trigger="ecc-notification";
        writable_mask=0x73;
        field { sw=rw; reset=0x73; } value[31:0];
    } APEC1ERRINT @ 0xFFF94804;
    reg {
        regwidth=32; accesswidth=32; access_widths="1,2,4"; desc="Write-one selected error flag/capture clear; zero is a no-op; reads zero";
        evidence="manual"; source_ref="R01UH0585EJ0120 Tables31.89,31.133-31.137"; behavior="storage";
        trigger="banked-ecc-clear";
        writable_mask=0x1;
        status_register="APEC11STERSTR";
        status_masks="0xc3";
        read_value=0x0;
        capture_registers="APEC11STEADR0";
        secondary_status_register="APEC1OVFSTR";
        secondary_status_masks="0x1";
        field { sw=w; reset=0x0; } value[31:0];
    } APEC1STCLR @ 0xFFF94808;
    reg {
        regwidth=32; accesswidth=32; access_widths="1,2,4"; desc="ECC error capture overflow latch; bit0 ERROVF";
        evidence="manual"; source_ref="R01UH0585EJ0120 Tables31.89,31.133-31.137"; behavior="storage";
        field { sw=r; reset=0x0; } value[31:0];
    } APEC1OVFSTR @ 0xFFF9480C;
    reg {
        regwidth=32; accesswidth=32; access_widths="1,2,4"; desc="ECC error status latches; only documented flag bits are cleared";
        evidence="manual"; source_ref="R01UH0585EJ0120 Tables31.89,31.133-31.137"; behavior="storage";
        field { sw=r; reset=0x0; } value[31:0];
    } APEC11STERSTR @ 0xFFF94810;
    reg {
        regwidth=32; accesswidth=32; desc="ECC error captured address";
        evidence="manual"; source_ref="R01UH0585EJ0120 Tables31.89,31.133-31.137"; behavior="storage";
        field { sw=r; reset=0x0; } value[31:0];
    } APEC11STEADR0 @ 0xFFF94850;
    reg {
        regwidth=32; accesswidth=32; access_widths="1,2,4"; desc="ECC error-report enable latches; reserved bits read reset; ECM delivery not synthesized";
        evidence="manual"; source_ref="R01UH0585EJ0120 Tables31.89,31.133-31.137"; behavior="storage";
        trigger="ecc-notification";
        writable_mask=0x73;
        field { sw=rw; reset=0x73; } value[31:0];
    } APEC2ERRINT @ 0xFFC40804;
    reg {
        regwidth=32; accesswidth=32; access_widths="1,2,4"; desc="Write-one selected error flag/capture clear; zero is a no-op; reads zero";
        evidence="manual"; source_ref="R01UH0585EJ0120 Tables31.89,31.133-31.137"; behavior="storage";
        trigger="banked-ecc-clear";
        writable_mask=0x1;
        status_register="APEC21STERSTR";
        status_masks="0xc3";
        read_value=0x0;
        capture_registers="APEC21STEADR0";
        secondary_status_register="APEC2OVFSTR";
        secondary_status_masks="0x1";
        field { sw=w; reset=0x0; } value[31:0];
    } APEC2STCLR @ 0xFFC40808;
    reg {
        regwidth=32; accesswidth=32; access_widths="1,2,4"; desc="ECC error capture overflow latch; bit0 ERROVF";
        evidence="manual"; source_ref="R01UH0585EJ0120 Tables31.89,31.133-31.137"; behavior="storage";
        field { sw=r; reset=0x0; } value[31:0];
    } APEC2OVFSTR @ 0xFFC4080C;
    reg {
        regwidth=32; accesswidth=32; access_widths="1,2,4"; desc="ECC error status latches; only documented flag bits are cleared";
        evidence="manual"; source_ref="R01UH0585EJ0120 Tables31.89,31.133-31.137"; behavior="storage";
        field { sw=r; reset=0x0; } value[31:0];
    } APEC21STERSTR @ 0xFFC40810;
    reg {
        regwidth=32; accesswidth=32; desc="ECC error captured address";
        evidence="manual"; source_ref="R01UH0585EJ0120 Tables31.89,31.133-31.137"; behavior="storage";
        field { sw=r; reset=0x0; } value[31:0];
    } APEC21STEADR0 @ 0xFFC40850;
    reg {
        regwidth=32; accesswidth=32; desc="DMA bus address ECC test control; simultaneous PROT31:30=01 permits ECCTST1/RWSEL0; key reads zero; no fault injection synthesized";
        evidence="manual"; source_ref="R01UH0585EJ0120 Table7.42"; behavior="storage";
        trigger="ecc-protected-control";
        writable_mask=0x3;
        protection_mask=0xc0000000;
        protection_value=0x40000000;
        field { sw=rw; reset=0x0; } value[31:0];
    } ADECCTCL @ 0xFFFF80A0;
    reg {
        regwidth=32; accesswidth=32; desc="DataFlash error capture overflow latch; bit0 ERROVF";
        evidence="manual"; source_ref="R01UH0585EJ0120 Tables31.17,31.21"; behavior="storage";
        field { sw=r; reset=0x0; } value[31:0];
    } DFOVFSTR @ 0xFFC5B00C;
    reg {
        regwidth=32; accesswidth=32; access_widths="1,2,4"; desc="Write-one selected error flag/capture clear; zero is a no-op; readback is not specified";
        evidence="manual"; source_ref="R01UH0585EJ0120 Tables31.17,31.22"; behavior="storage";
        trigger="banked-ecc-clear";
        writable_mask=0x1;
        status_register="DFOVFSTR";
        status_masks="0x1";
        read_input=true;
        field { sw=w; reset=0x0; } value[31:0];
    } DFOVFSTC @ 0xFFC5B010;

    reg {
        regwidth=32; accesswidth=16; access_widths="2,4"; desc="Local-RAM ECC control for PE1; PROT[15:14]=01 permits SECDIS/ECCDIS low2-bit update, protection bits read0";
        evidence="manual"; source_ref="R01UH0585EJ0120 page2551 Table31.28"; behavior="storage";
        trigger="ecc-protected-control"; writable_mask=3;
        field { sw=rw; reset=0; } value[31:0];
    } LRECCCTL_PE1 @ 0xFFC65400;

    reg {
        regwidth=32; accesswidth=32; desc="Local-RAM test control; protected ECCTST and DATSEL fields, no error injection synthesized";
        evidence="manual"; source_ref="R01UH0585EJ0120 page2560 Table31.37"; behavior="storage";
        trigger="ecc-protected-control"; writable_mask=3;
        field { sw=rw; reset=0; } value[31:0];
    } LRTSTCTL_PE1 @ 0xFFC65604;

    reg {
        regwidth=32; accesswidth=16; access_widths="2,4"; desc="Global-RAM address/data ECC control; writable ASECDIS, AECCDIS, SECDIS and ECCDIS, bit2 reserved";
        evidence="manual"; source_ref="R01UH0585EJ0120 page2576 Table31.50"; behavior="storage";
        trigger="ecc-protected-control"; writable_mask=0x1B;
        field { sw=rw; reset=0; } value[31:0];
    } GRECCCTL_GRAMC @ 0xFFC64100;

    reg {
        regwidth=32; accesswidth=16; access_widths="2,4"; desc="Global-RAM test control; protected ECCTST, DECINEN and DATSEL fields, no error injection synthesized";
        evidence="manual"; source_ref="R01UH0585EJ0120 page2577 Table31.51"; behavior="storage";
        trigger="ecc-protected-control"; writable_mask=0xF;
        field { sw=rw; reset=0; } value[31:0];
    } GRTSTCTL @ 0xFFC64104;

    reg {
        regwidth=32; accesswidth=16; access_widths="2,4"; desc="Global-RAM system-interconnect ECC control; protected SECDIS/ECCDIS fields";
        evidence="manual"; source_ref="R01UH0585EJ0120 page2582 Table31.55"; behavior="storage";
        trigger="ecc-protected-control"; writable_mask=3;
        field { sw=rw; reset=0; } value[31:0];
    } GRECCCTL_VCI2GRAM @ 0xFFC64200;

    reg {
        regwidth=32; accesswidth=16; access_widths="2,4"; desc="Global-RAM AXI ECC control; protected SECDIS/ECCDIS fields";
        evidence="manual"; source_ref="R01UH0585EJ0120 page2582 Table31.55"; behavior="storage";
        trigger="ecc-protected-control"; writable_mask=3;
        field { sw=rw; reset=0; } value[31:0];
    } GRECCCTL_AXI2GRAM @ 0xFFC64E00;

    reg {
        regwidth=32; accesswidth=16; access_widths="2,4"; desc="CodeFlash address-ECC control; protected ASECDIS/AECCDIS at bits3:2, bits1:0 reserved";
        evidence="manual"; source_ref="R01UH0585EJ0120 page2625 Table31.90"; behavior="storage";
        trigger="ecc-protected-control"; writable_mask=0xC;
        field { sw=rw; reset=0; } value[31:0];
    } CFECCCTL_VCI2CFBB @ 0xFFC62C00;

    reg {
        regwidth=32; accesswidth=16; access_widths="2,4"; desc="Instruction-fetch ECC control; protected SECDIS/ECCDIS fields";
        evidence="manual"; source_ref="R01UH0585EJ0120 page2631 Table31.96"; behavior="storage";
        trigger="ecc-protected-control"; writable_mask=3;
        field { sw=rw; reset=0; } value[31:0];
    } IFECCCTL_PE1 @ 0xFFC63400;

    reg {
        regwidth=32; accesswidth=16; access_widths="2,4"; desc="Load/store slave ECC control; protected SECDIS/ECCDIS fields";
        evidence="manual"; source_ref="R01UH0585EJ0120 page2637 Table31.102"; behavior="storage";
        trigger="ecc-protected-control"; writable_mask=3;
        field { sw=rw; reset=0; } value[31:0];
    } LSSECCCTL_PE1 @ 0xFFC66000;

    reg {
        regwidth=32; accesswidth=16; access_widths="2,4"; desc="Load/store master ECC control; protected SECDIS/ECCDIS fields";
        evidence="manual"; source_ref="R01UH0585EJ0120 page2643 Table31.108"; behavior="storage";
        trigger="ecc-protected-control"; writable_mask=3;
        field { sw=rw; reset=0; } value[31:0];
    } LSMECCCTL_PE1 @ 0xFFC66400;

    reg {
        regwidth=32; accesswidth=16; access_widths="2,4"; desc="Peripheral-DMA ECC control; protected SECDIS/ECCDIS fields";
        evidence="manual"; source_ref="R01UH0585EJ0120 page2654 Table31.119"; behavior="storage";
        trigger="ecc-protected-control"; writable_mask=3;
        field { sw=rw; reset=0; } value[31:0];
    } VCECCCTL_PDMA @ 0xFFC6A000;

    reg {
        regwidth=32; accesswidth=16; access_widths="2,4"; desc="Peripheral-subsystem address/data ECC control; protected low4 fields";
        evidence="manual"; source_ref="R01UH0585EJ0120 page2660 Table31.125"; behavior="storage";
        trigger="ecc-protected-control"; writable_mask=0xF;
        field { sw=rw; reset=0; } value[31:0];
    } APECCCTL_PFSS @ 0xFFC6C000;

    reg {
        regwidth=32; accesswidth=16; access_widths="2,4"; desc="Peripheral IP group1 address/data ECC control; protected low4 fields";
        evidence="manual"; source_ref="R01UH0585EJ0120 page2666 Tables31.131-31.132"; behavior="storage";
        trigger="ecc-protected-control"; writable_mask=0xF;
        field { sw=rw; reset=0; } value[31:0];
    } APEC0ECCCTL @ 0xFFDDD800;

    reg {
        regwidth=32; accesswidth=16; access_widths="2,4"; desc="Peripheral IP group2 address/data ECC control; protected low4 fields";
        evidence="manual"; source_ref="R01UH0585EJ0120 page2666 Tables31.131-31.132"; behavior="storage";
        trigger="ecc-protected-control"; writable_mask=0xF;
        field { sw=rw; reset=0; } value[31:0];
    } APEC1ECCCTL @ 0xFFF94800;

    reg {
        regwidth=32; accesswidth=16; access_widths="2,4"; desc="Peripheral IP group5 address/data ECC control; protected low4 fields";
        evidence="manual"; source_ref="R01UH0585EJ0120 page2666 Tables31.131-31.132"; behavior="storage";
        trigger="ecc-protected-control"; writable_mask=0xF;
        field { sw=rw; reset=0; } value[31:0];
    } APEC2ECCCTL @ 0xFFC40800;

    reg {
        regwidth=32; accesswidth=32; desc="RSCFD0CFDCFCC3 (CFCCk = base+0x118+4k, k=3): CFIFO 3 configuration and control; CFE bit 0 enable, CFRXIE bit 1 receive-interrupt enable, CFTXIE bit 2 transmit-interrupt enable, CFPLS[6:4] payload size, CFDC[10:8] depth (0,4,8,16,32,48,64,128 messages), CFIM bit 12 interrupt source (1=every message), CFIGCV[15:13] fill threshold eighths, CFM[17:16] mode 00=receive; FIFO 3 serves CAN channel m=k/3=1";
        evidence="manual"; source_ref="R01UH0585EJ0120 Tables 17.12 and 17.132, section 17.4.8.1 (pages 797, 989-992)"; behavior="rscfd";
        status_register="CFSTS_CH1"; pointer_register="CFPCTR_CH1"; window_register="CFID_CH1"; channel_control_register="C1CTR"; global_control_register="GCTR"; interrupt_register="EIC187"; fifo_index=3; fifo_channel=1;
        field { sw=rw; reset=0; } value[31:0];
    } CFCC3 @ 0xFFD20124;

    reg {
        regwidth=32; accesswidth=32; desc="RSCFD common-FIFO status base (CFSTSk = base+0x178+4k, k=0..8)";
        evidence="manual"; source_ref="R01UH0585EJ0120 Tables 17.12 and 17.133; firmware-observed role"; behavior="rscfd";
        field { sw=rw; } value[31:0];
    } CFSTS @ 0xFFD20178;

    reg {
        regwidth=32; accesswidth=32; desc="RSCFD0CFDCFSTS3 (CFSTSk = base+0x178+4k, k=3): transmit/receive FIFO 3 status; CAN channel m=k/3=1; CFMC[15:8] message count, CFTXIF bit 4, CFRXIF bit 3, CFMLT bit 2, CFFLL bit 1, CFEMP bit 0; flags clear on write 0 to the flag with 1 elsewhere; reset CFEMP=1";
        evidence="manual"; source_ref="R01UH0585EJ0120 Tables 17.12 and 17.133, section 17.4.8.2 (pages 797, 992-995); SFR list FFD20184; firmware table 0x22FA0 stores this FIFO-3 base while native reader 0x83D40 computes the operative CFSTS5 at +8"; behavior="rscfd";
        control_register="CFCC3"; pointer_register="CFPCTR_CH1"; interrupt_register="EIC187"; fifo_index=3; fifo_channel=1;
        field { sw=rw; reset=1; } value[31:0];
    } CFSTS_CH1 @ 0xFFD20184;

    reg {
        regwidth=32; accesswidth=32; desc="RSCFD common-FIFO pointer control base (CFPCTRk = base+0x1D8+4k, k=0..8; write 0xFF to CFPC[7:0] advances)";
        evidence="manual"; source_ref="R01UH0585EJ0120 section 17, RSCFD register tables; firmware-observed role"; behavior="rscfd";
        field { sw=rw; } value[31:0];
    } CFPCTR @ 0xFFD201D8;

    reg {
        regwidth=32; accesswidth=32; desc="RSCFD0CFDCFPCTR3 (CFPCTRk = base+0x1D8+4k, k=3): CFIFO 3 pointer control; CFPC[7:0] write-only; receive mode: write 0xFF moves the read pointer to the next unread message and decrements CFMC (requires CFE=1 and CFEMP=0)";
        evidence="manual"; source_ref="R01UH0585EJ0120 Tables 17.12 and 17.134, section 17.4.8.3 (pages 797, 996-997); SFR list FFD201E4; firmware table 0x22FAC stores this FIFO-3 base while native reader 0x83D40 computes the operative CFPCTR5 at +8"; behavior="rscfd";
        status_register="CFSTS_CH1"; control_register="CFCC3"; fifo_index=3; fifo_channel=1;
        field { sw=w; } value[31:0];
    } CFPCTR_CH1 @ 0xFFD201E4;

    reg {
        regwidth=32; accesswidth=32; desc="RSCFD Tx message-buffer control base (CFDTMCn.TMTR at +n)";
        evidence="manual"; source_ref="R01UH0585EJ0120 section 17, RSCFD register tables; firmware-observed role"; behavior="rscfd";
        field { sw=rw; } value[31:0];
    } CFDTMC @ 0xFFD20250;

    reg {
        regwidth=8; accesswidth=8; desc="Diagnostic Tx buffer control (HTH 0x13 -> n=16; TMTR bit 0)";
        evidence="manual"; source_ref="R01UH0585EJ0120 section 17, RSCFD register tables; firmware-observed role"; behavior="rscfd";
        trigger="rscfd-transmit"; payload_address=0xFFD24200; status_register="CFDTMSTS_CH1"; completion_value=4;
        field { sw=rw; } value[7:0];
    } CFDTMC16 @ 0xFFD20260;

    reg {
        regwidth=8; accesswidth=8; desc="Application CAN1 Tx buffer n=16 control (TMTR bit 0)";
        evidence="manual"; source_ref="R01UH0585EJ0120 section 17, RSCFD register tables; exact firmware table binding"; behavior="rscfd";
        trigger="rscfd-transmit"; payload_address=0xFFD24400; status_register="CFDTMSTS_CH1_16"; completion_value=4;
        field { sw=rw; } value[7:0];
    } CFDTMC_CH1_16 @ 0xFFD20270;

    reg {
        regwidth=8; accesswidth=8; desc="Application CAN1 Tx buffer local resource 6 control (TMTR bit 0)";
        evidence="manual"; source_ref="R01UH0585EJ0120 section 17, RSCFD register tables; exact registered-firmware response route";
        behavior="rscfd"; trigger="rscfd-transmit"; payload_address=0xFFD242C0; status_register="CFDTMSTS_CH1_6"; completion_value=4;
        field { sw=rw; } value[7:0];
    } CFDTMC_CH1_6 @ 0xFFD20266;

    reg {
        regwidth=8; accesswidth=8; desc="Application CAN1 Tx buffer local resource 7 control (TMTR bit 0)";
        evidence="manual"; source_ref="R01UH0585EJ0120 section 17, RSCFD register tables; exact registered-firmware response route";
        behavior="rscfd"; trigger="rscfd-transmit"; payload_address=0xFFD242E0; status_register="CFDTMSTS_CH1_7"; completion_value=4;
        field { sw=rw; } value[7:0];
    } CFDTMC_CH1_7 @ 0xFFD20267;

    reg {
        regwidth=32; accesswidth=32; desc="RSCFD Tx message-buffer status base (CFDTMSTSn at +n)";
        evidence="manual"; source_ref="R01UH0585EJ0120 section 17, RSCFD register tables; firmware-observed role"; behavior="rscfd";
        field { sw=rw; } value[31:0];
    } CFDTMSTS @ 0xFFD202D0;

    reg {
        regwidth=32; accesswidth=32; desc="RSCFD Tx status base for application CAN1 record";
        evidence="manual"; source_ref="R01UH0585EJ0120 section 17, RSCFD register tables; firmware-observed role"; behavior="rscfd";
        field { sw=rw; } value[31:0];
    } CFDTMSTS_CH1 @ 0xFFD202E0;

    reg {
        regwidth=8; accesswidth=8; desc="Application CAN1 Tx buffer n=16 status";
        evidence="manual"; source_ref="R01UH0585EJ0120 section 17, RSCFD register tables; exact firmware table binding"; behavior="rscfd";
        field { sw=rw; } value[7:0];
    } CFDTMSTS_CH1_16 @ 0xFFD202F0;

    reg {
        regwidth=8; accesswidth=8; desc="Application CAN1 Tx buffer local resource 6 status";
        evidence="manual"; source_ref="R01UH0585EJ0120 section 17, RSCFD register tables; exact registered-firmware response route";
        behavior="rscfd";
        field { sw=rw; reset=0; } value[7:0];
    } CFDTMSTS_CH1_6 @ 0xFFD202E6;

    reg {
        regwidth=8; accesswidth=8; desc="Application CAN1 Tx buffer local resource 7 status";
        evidence="manual"; source_ref="R01UH0585EJ0120 section 17, RSCFD register tables; exact registered-firmware response route";
        behavior="rscfd";
        field { sw=rw; reset=0; } value[7:0];
    } CFDTMSTS_CH1_7 @ 0xFFD202E7;

    reg {
        regwidth=32; accesswidth=32; desc="RSCFD common-FIFO access-window base (CFIDk = base+0x3400+0x80k, k=0..8; window: ID, +4 PTR, +8 FDCSTS, +0x0C..+0x48 DF0..DF15)";
        evidence="manual"; source_ref="R01UH0585EJ0120 section 17, RSCFD register tables; firmware-observed role"; behavior="rscfd";
        field { sw=rw; } value[31:0];
    } CFID @ 0xFFD23400;

    reg {
        regwidth=32; accesswidth=32; desc="RSCFD0CFDCFID3 (CFIDk = base+0x3400+0x80k, k=3): CFIFO 3 access window; CFIDE bit 31, CFRTR bit 30, CFID[28:0]; +0x04 CFDCFPTR3 (CFDLC[31:28], CFPTR[27:16], CFTS[15:0]), +0x08 CFDCFFDCSTS3 (CFFDF bit 2, CFBRS bit 1, CFESI bit 0), +0x0C CFDCFDF0_3 .. +0x48 CFDCFDF15_3 (16 data words); receive mode reads alias the oldest unread message";
        evidence="manual"; source_ref="R01UH0585EJ0120 Tables 17.12, 17.135-17.138, section 17.4.8.4-17.4.8.7 (pages 797-798, 997-1004); SFR list FFD23580-FFD235C8; firmware table 0x22FB4 stores this FIFO-3 window base while native reader 0x83D40 computes the operative CFID5 at +0x100"; behavior="rscfd";
        status_register="CFSTS_CH1"; fifo_index=3; fifo_channel=1;
        access_widths="1,2,4";
        field { sw=r; reset=0; } value[31:0];
    } CFID_CH1 @ 0xFFD23580;

    reg {
        regwidth=32; accesswidth=32; desc="RSCFD0CFDCFPTR3 (CFID3 window +0x04): CFIFO 3 access pointer; CFDLC[31:28] DLC of the unread message (CAN FD: 9-15 = 12/16/20/24/32/48/64 bytes), CFPTR[27:16] label, CFTS[15:0] timestamp; read-only in receive mode";
        evidence="manual"; source_ref="R01UH0585EJ0120 Table 17.136, section 17.4.8.5 (pages 999-1001); SFR list FFD23584"; behavior="rscfd";
        status_register="CFSTS_CH1"; fifo_index=3; fifo_channel=1;
        access_widths="1,2,4";
        field { sw=r; reset=0; } value[31:0];
    } CFPTR_CH1 @ 0xFFD23584;

    reg {
        regwidth=32; accesswidth=32; desc="RSCFD0CFDCFFDCSTS3 (CFID3 window +0x08): CFIFO 3 CAN FD configuration/status; CFFDF bit 2 (1=CAN FD frame), CFBRS bit 1, CFESI bit 0";
        evidence="manual"; source_ref="R01UH0585EJ0120 Table 17.137, section 17.4.8.6 (pages 1001-1002); SFR list FFD23588"; behavior="rscfd";
        status_register="CFSTS_CH1"; fifo_index=3; fifo_channel=1;
        access_widths="1,2,4";
        field { sw=r; reset=0; } value[31:0];
    } CFFDCSTS_CH1 @ 0xFFD23588;

    reg {
        regwidth=32; accesswidth=32; desc="RSCFD0CFDCFDF0_3 (CFID3 window +0x0C): CFIFO 3 unread-message data bytes 0..3; read-only in receive mode";
        evidence="manual"; source_ref="R01UH0585EJ0120 section 17.4.8.7, Tables 17.12 and 17.138 (page 1003); SFR list FFD2358C"; behavior="rscfd";
        status_register="CFSTS_CH1"; fifo_index=3; fifo_channel=1;
        access_widths="1,2,4";
        field { sw=r; reset=0; } value[31:0];
    } CFDF0_CH1 @ 0xFFD2358C;

    reg {
        regwidth=32; accesswidth=32; desc="RSCFD0CFDCFDF1_3 (CFID3 window +0x10): CFIFO 3 unread-message data bytes 4..7; read-only in receive mode";
        evidence="manual"; source_ref="R01UH0585EJ0120 section 17.4.8.7, Tables 17.12 and 17.138 (page 1003); SFR list FFD23590"; behavior="rscfd";
        status_register="CFSTS_CH1"; fifo_index=3; fifo_channel=1;
        access_widths="1,2,4";
        field { sw=r; reset=0; } value[31:0];
    } CFDF1_CH1 @ 0xFFD23590;

    reg {
        regwidth=32; accesswidth=32; desc="RSCFD0CFDCFDF2_3 (CFID3 window +0x14): CFIFO 3 unread-message data bytes 8..11; read-only in receive mode";
        evidence="manual"; source_ref="R01UH0585EJ0120 section 17.4.8.7, Tables 17.12 and 17.138 (page 1003); SFR list FFD23594"; behavior="rscfd";
        status_register="CFSTS_CH1"; fifo_index=3; fifo_channel=1;
        access_widths="1,2,4";
        field { sw=r; reset=0; } value[31:0];
    } CFDF2_CH1 @ 0xFFD23594;

    reg {
        regwidth=32; accesswidth=32; desc="RSCFD0CFDCFDF3_3 (CFID3 window +0x18): CFIFO 3 unread-message data bytes 12..15; read-only in receive mode";
        evidence="manual"; source_ref="R01UH0585EJ0120 section 17.4.8.7, Tables 17.12 and 17.138 (page 1003); SFR list FFD23598"; behavior="rscfd";
        status_register="CFSTS_CH1"; fifo_index=3; fifo_channel=1;
        access_widths="1,2,4";
        field { sw=r; reset=0; } value[31:0];
    } CFDF3_CH1 @ 0xFFD23598;

    reg {
        regwidth=32; accesswidth=32; desc="RSCFD0CFDCFDF4_3 (CFID3 window +0x1C): CFIFO 3 unread-message data bytes 16..19; read-only in receive mode";
        evidence="manual"; source_ref="R01UH0585EJ0120 section 17.4.8.7, Tables 17.12 and 17.138 (page 1003); SFR list FFD2359C"; behavior="rscfd";
        status_register="CFSTS_CH1"; fifo_index=3; fifo_channel=1;
        access_widths="1,2,4";
        field { sw=r; reset=0; } value[31:0];
    } CFDF4_CH1 @ 0xFFD2359C;

    reg {
        regwidth=32; accesswidth=32; desc="RSCFD0CFDCFDF5_3 (CFID3 window +0x20): CFIFO 3 unread-message data bytes 20..23; read-only in receive mode";
        evidence="manual"; source_ref="R01UH0585EJ0120 section 17.4.8.7, Tables 17.12 and 17.138 (page 1003); SFR list FFD235A0"; behavior="rscfd";
        status_register="CFSTS_CH1"; fifo_index=3; fifo_channel=1;
        access_widths="1,2,4";
        field { sw=r; reset=0; } value[31:0];
    } CFDF5_CH1 @ 0xFFD235A0;

    reg {
        regwidth=32; accesswidth=32; desc="RSCFD0CFDCFDF6_3 (CFID3 window +0x24): CFIFO 3 unread-message data bytes 24..27; read-only in receive mode";
        evidence="manual"; source_ref="R01UH0585EJ0120 section 17.4.8.7, Tables 17.12 and 17.138 (page 1003); SFR list FFD235A4"; behavior="rscfd";
        status_register="CFSTS_CH1"; fifo_index=3; fifo_channel=1;
        access_widths="1,2,4";
        field { sw=r; reset=0; } value[31:0];
    } CFDF6_CH1 @ 0xFFD235A4;

    reg {
        regwidth=32; accesswidth=32; desc="RSCFD0CFDCFDF7_3 (CFID3 window +0x28): CFIFO 3 unread-message data bytes 28..31; read-only in receive mode";
        evidence="manual"; source_ref="R01UH0585EJ0120 section 17.4.8.7, Tables 17.12 and 17.138 (page 1003); SFR list FFD235A8"; behavior="rscfd";
        status_register="CFSTS_CH1"; fifo_index=3; fifo_channel=1;
        access_widths="1,2,4";
        field { sw=r; reset=0; } value[31:0];
    } CFDF7_CH1 @ 0xFFD235A8;

    reg {
        regwidth=32; accesswidth=32; desc="RSCFD0CFDCFDF8_3 (CFID3 window +0x2C): CFIFO 3 unread-message data bytes 32..35; read-only in receive mode";
        evidence="manual"; source_ref="R01UH0585EJ0120 section 17.4.8.7, Tables 17.12 and 17.138 (page 1003); SFR list FFD235AC"; behavior="rscfd";
        status_register="CFSTS_CH1"; fifo_index=3; fifo_channel=1;
        access_widths="1,2,4";
        field { sw=r; reset=0; } value[31:0];
    } CFDF8_CH1 @ 0xFFD235AC;

    reg {
        regwidth=32; accesswidth=32; desc="RSCFD0CFDCFDF9_3 (CFID3 window +0x30): CFIFO 3 unread-message data bytes 36..39; read-only in receive mode";
        evidence="manual"; source_ref="R01UH0585EJ0120 section 17.4.8.7, Tables 17.12 and 17.138 (page 1003); SFR list FFD235B0"; behavior="rscfd";
        status_register="CFSTS_CH1"; fifo_index=3; fifo_channel=1;
        access_widths="1,2,4";
        field { sw=r; reset=0; } value[31:0];
    } CFDF9_CH1 @ 0xFFD235B0;

    reg {
        regwidth=32; accesswidth=32; desc="RSCFD0CFDCFDF10_3 (CFID3 window +0x34): CFIFO 3 unread-message data bytes 40..43; read-only in receive mode";
        evidence="manual"; source_ref="R01UH0585EJ0120 section 17.4.8.7, Tables 17.12 and 17.138 (page 1003); SFR list FFD235B4"; behavior="rscfd";
        status_register="CFSTS_CH1"; fifo_index=3; fifo_channel=1;
        access_widths="1,2,4";
        field { sw=r; reset=0; } value[31:0];
    } CFDF10_CH1 @ 0xFFD235B4;

    reg {
        regwidth=32; accesswidth=32; desc="RSCFD0CFDCFDF11_3 (CFID3 window +0x38): CFIFO 3 unread-message data bytes 44..47; read-only in receive mode";
        evidence="manual"; source_ref="R01UH0585EJ0120 section 17.4.8.7, Tables 17.12 and 17.138 (page 1003); SFR list FFD235B8"; behavior="rscfd";
        status_register="CFSTS_CH1"; fifo_index=3; fifo_channel=1;
        access_widths="1,2,4";
        field { sw=r; reset=0; } value[31:0];
    } CFDF11_CH1 @ 0xFFD235B8;

    reg {
        regwidth=32; accesswidth=32; desc="RSCFD0CFDCFDF12_3 (CFID3 window +0x3C): CFIFO 3 unread-message data bytes 48..51; read-only in receive mode";
        evidence="manual"; source_ref="R01UH0585EJ0120 section 17.4.8.7, Tables 17.12 and 17.138 (page 1003); SFR list FFD235BC"; behavior="rscfd";
        status_register="CFSTS_CH1"; fifo_index=3; fifo_channel=1;
        access_widths="1,2,4";
        field { sw=r; reset=0; } value[31:0];
    } CFDF12_CH1 @ 0xFFD235BC;

    reg {
        regwidth=32; accesswidth=32; desc="RSCFD0CFDCFDF13_3 (CFID3 window +0x40): CFIFO 3 unread-message data bytes 52..55; read-only in receive mode";
        evidence="manual"; source_ref="R01UH0585EJ0120 section 17.4.8.7, Tables 17.12 and 17.138 (page 1003); SFR list FFD235C0"; behavior="rscfd";
        status_register="CFSTS_CH1"; fifo_index=3; fifo_channel=1;
        access_widths="1,2,4";
        field { sw=r; reset=0; } value[31:0];
    } CFDF13_CH1 @ 0xFFD235C0;

    reg {
        regwidth=32; accesswidth=32; desc="RSCFD0CFDCFDF14_3 (CFID3 window +0x44): CFIFO 3 unread-message data bytes 56..59; read-only in receive mode";
        evidence="manual"; source_ref="R01UH0585EJ0120 section 17.4.8.7, Tables 17.12 and 17.138 (page 1003); SFR list FFD235C4"; behavior="rscfd";
        status_register="CFSTS_CH1"; fifo_index=3; fifo_channel=1;
        access_widths="1,2,4";
        field { sw=r; reset=0; } value[31:0];
    } CFDF14_CH1 @ 0xFFD235C4;

    reg {
        regwidth=32; accesswidth=32; desc="RSCFD0CFDCFDF15_3 (CFID3 window +0x48): CFIFO 3 unread-message data bytes 60..63; read-only in receive mode";
        evidence="manual"; source_ref="R01UH0585EJ0120 section 17.4.8.7, Tables 17.12 and 17.138 (page 1003); SFR list FFD235C8"; behavior="rscfd";
        status_register="CFSTS_CH1"; fifo_index=3; fifo_channel=1;
        access_widths="1,2,4";
        field { sw=r; reset=0; } value[31:0];
    } CFDF15_CH1 @ 0xFFD235C8;

    reg {
        regwidth=32; accesswidth=32; desc="RSCFD0CFDCFCC5 (CFCCk = base+0x118+4k, k=5): CFIFO 5 configuration and control; CFE bit 0 enable, CFRXIE bit 1 receive-interrupt enable, CFTXIE bit 2 transmit-interrupt enable, CFPLS[6:4] payload size, CFDC[10:8] depth (0,4,8,16,32,48,64,128 messages), CFIM bit 12 interrupt source (1=every message), CFIGCV[15:13] fill threshold eighths, CFM[17:16] mode 00=receive; FIFO 5 serves CAN channel m=k/3=1; native diagnostic receive path: firmware config tables 0x22F68/0x22F6C store C1CTR/C1STS and 0x22FA0-0x22FB4 store FIFO-3 bases, and reader 0x83D40 computes the operative FIFO-5 registers by adding +8 to status/pointer/control and +0x100 to the window; GAFL rule 43 (GAFLID 0x7A1, label 0x34, GAFLFDP 0x2000 = bit 13-8 = k 5) targets this FIFO";
        evidence="manual"; source_ref="R01UH0585EJ0120 Tables 17.12 and 17.132, section 17.4.8.1 (pages 797, 989-992); SFR list FFD2012C; exact-firmware FIFO-5 selection at FFD2012C = stored base FFD20124 + 8"; behavior="rscfd";
        status_register="CFSTS5"; pointer_register="CFPCTR5"; window_register="CFID5"; channel_control_register="C1CTR"; global_control_register="GCTR"; interrupt_register="EIC187"; fifo_index=5; fifo_channel=1;
        field { sw=rw; reset=0; } value[31:0];
    } CFCC5 @ 0xFFD2012C;

    reg {
        regwidth=32; accesswidth=32; desc="RSCFD0CFDCFSTS5 (CFSTSk = base+0x178+4k, k=5): transmit/receive FIFO 5 status; CAN channel m=k/3=1; CFMC[15:8] message count, CFTXIF bit 4, CFRXIF bit 3, CFMLT bit 2, CFFLL bit 1, CFEMP bit 0; flags clear on write 0 to the flag with 1 elsewhere; reset CFEMP=1";
        evidence="manual"; source_ref="R01UH0585EJ0120 Tables 17.12 and 17.133, section 17.4.8.2 (pages 797, 992-995); SFR list FFD2018C; exact-firmware FIFO-5 selection at FFD2018C = stored base FFD20184 + 8"; behavior="rscfd";
        control_register="CFCC5"; pointer_register="CFPCTR5"; interrupt_register="EIC187"; fifo_index=5; fifo_channel=1;
        field { sw=rw; reset=1; } value[31:0];
    } CFSTS5 @ 0xFFD2018C;

    reg {
        regwidth=32; accesswidth=32; desc="RSCFD0CFDCFPCTR5 (CFPCTRk = base+0x1D8+4k, k=5): CFIFO 5 pointer control; CFPC[7:0] write-only; receive mode: write 0xFF moves the read pointer to the next unread message and decrements CFMC (requires CFE=1 and CFEMP=0)";
        evidence="manual"; source_ref="R01UH0585EJ0120 Tables 17.12 and 17.134, section 17.4.8.3 (pages 797, 996-997); SFR list FFD201EC; exact-firmware FIFO-5 selection at FFD201EC = stored base FFD201E4 + 8"; behavior="rscfd";
        status_register="CFSTS5"; control_register="CFCC5"; fifo_index=5; fifo_channel=1;
        field { sw=w; } value[31:0];
    } CFPCTR5 @ 0xFFD201EC;

    reg {
        regwidth=32; accesswidth=32; desc="RSCFD0CFDCFID5 (CFIDk = base+0x3400+0x80k, k=5): CFIFO 5 access window; CFIDE bit 31, CFRTR bit 30, CFID[28:0]; +0x04 CFDCFPTR5 (CFDLC[31:28], CFPTR[27:16], CFTS[15:0]), +0x08 CFDCFFDCSTS5 (CFFDF bit 2, CFBRS bit 1, CFESI bit 0), +0x0C CFDCFDF0_5 .. +0x48 CFDCFDF15_5 (16 data words); receive mode reads alias the oldest unread message";
        evidence="manual"; source_ref="R01UH0585EJ0120 Tables 17.12, 17.135-17.138, section 17.4.8.4-17.4.8.7 (pages 797-798, 997-1004); SFR list FFD23680-FFD236C8; exact-firmware FIFO-5 selection at FFD23680 = stored base FFD23580 + 0x100"; behavior="rscfd";
        status_register="CFSTS5"; fifo_index=5; fifo_channel=1;
        access_widths="1,2,4";
        field { sw=r; reset=0; } value[31:0];
    } CFID5 @ 0xFFD23680;

    reg {
        regwidth=32; accesswidth=32; desc="RSCFD0CFDCFPTR5 (CFID5 window +0x04): CFIFO 5 access pointer; CFDLC[31:28] DLC of the unread message (CAN FD: 9-15 = 12/16/20/24/32/48/64 bytes), CFPTR[27:16] label, CFTS[15:0] timestamp; read-only in receive mode";
        evidence="manual"; source_ref="R01UH0585EJ0120 Table 17.136, section 17.4.8.5 (pages 999-1001); SFR list FFD23684"; behavior="rscfd";
        status_register="CFSTS5"; fifo_index=5; fifo_channel=1;
        access_widths="1,2,4";
        field { sw=r; reset=0; } value[31:0];
    } CFPTR5 @ 0xFFD23684;

    reg {
        regwidth=32; accesswidth=32; desc="RSCFD0CFDCFFDCSTS5 (CFID5 window +0x08): CFIFO 5 CAN FD configuration/status; CFFDF bit 2 (1=CAN FD frame), CFBRS bit 1, CFESI bit 0";
        evidence="manual"; source_ref="R01UH0585EJ0120 Table 17.137, section 17.4.8.6 (pages 1001-1002); SFR list FFD23688"; behavior="rscfd";
        status_register="CFSTS5"; fifo_index=5; fifo_channel=1;
        access_widths="1,2,4";
        field { sw=r; reset=0; } value[31:0];
    } CFFDCSTS5 @ 0xFFD23688;

    reg {
        regwidth=32; accesswidth=32; desc="RSCFD0CFDCFDF0_5 (CFID5 window +0x0C): CFIFO 5 unread-message data bytes 0..3; read-only in receive mode";
        evidence="manual"; source_ref="R01UH0585EJ0120 section 17.4.8.7, Tables 17.12 and 17.138 (page 1003); SFR list FFD2368C"; behavior="rscfd";
        status_register="CFSTS5"; fifo_index=5; fifo_channel=1;
        access_widths="1,2,4";
        field { sw=r; reset=0; } value[31:0];
    } CFDF0_5 @ 0xFFD2368C;

    reg {
        regwidth=32; accesswidth=32; desc="RSCFD0CFDCFDF1_5 (CFID5 window +0x10): CFIFO 5 unread-message data bytes 4..7; read-only in receive mode";
        evidence="manual"; source_ref="R01UH0585EJ0120 section 17.4.8.7, Tables 17.12 and 17.138 (page 1003); SFR list FFD23690"; behavior="rscfd";
        status_register="CFSTS5"; fifo_index=5; fifo_channel=1;
        access_widths="1,2,4";
        field { sw=r; reset=0; } value[31:0];
    } CFDF1_5 @ 0xFFD23690;

    reg {
        regwidth=32; accesswidth=32; desc="RSCFD0CFDCFDF2_5 (CFID5 window +0x14): CFIFO 5 unread-message data bytes 8..11; read-only in receive mode";
        evidence="manual"; source_ref="R01UH0585EJ0120 section 17.4.8.7, Tables 17.12 and 17.138 (page 1003); SFR list FFD23694"; behavior="rscfd";
        status_register="CFSTS5"; fifo_index=5; fifo_channel=1;
        access_widths="1,2,4";
        field { sw=r; reset=0; } value[31:0];
    } CFDF2_5 @ 0xFFD23694;

    reg {
        regwidth=32; accesswidth=32; desc="RSCFD0CFDCFDF3_5 (CFID5 window +0x18): CFIFO 5 unread-message data bytes 12..15; read-only in receive mode";
        evidence="manual"; source_ref="R01UH0585EJ0120 section 17.4.8.7, Tables 17.12 and 17.138 (page 1003); SFR list FFD23698"; behavior="rscfd";
        status_register="CFSTS5"; fifo_index=5; fifo_channel=1;
        access_widths="1,2,4";
        field { sw=r; reset=0; } value[31:0];
    } CFDF3_5 @ 0xFFD23698;

    reg {
        regwidth=32; accesswidth=32; desc="RSCFD0CFDCFDF4_5 (CFID5 window +0x1C): CFIFO 5 unread-message data bytes 16..19; read-only in receive mode";
        evidence="manual"; source_ref="R01UH0585EJ0120 section 17.4.8.7, Tables 17.12 and 17.138 (page 1003); SFR list FFD2369C"; behavior="rscfd";
        status_register="CFSTS5"; fifo_index=5; fifo_channel=1;
        access_widths="1,2,4";
        field { sw=r; reset=0; } value[31:0];
    } CFDF4_5 @ 0xFFD2369C;

    reg {
        regwidth=32; accesswidth=32; desc="RSCFD0CFDCFDF5_5 (CFID5 window +0x20): CFIFO 5 unread-message data bytes 20..23; read-only in receive mode";
        evidence="manual"; source_ref="R01UH0585EJ0120 section 17.4.8.7, Tables 17.12 and 17.138 (page 1003); SFR list FFD236A0"; behavior="rscfd";
        status_register="CFSTS5"; fifo_index=5; fifo_channel=1;
        access_widths="1,2,4";
        field { sw=r; reset=0; } value[31:0];
    } CFDF5_5 @ 0xFFD236A0;

    reg {
        regwidth=32; accesswidth=32; desc="RSCFD0CFDCFDF6_5 (CFID5 window +0x24): CFIFO 5 unread-message data bytes 24..27; read-only in receive mode";
        evidence="manual"; source_ref="R01UH0585EJ0120 section 17.4.8.7, Tables 17.12 and 17.138 (page 1003); SFR list FFD236A4"; behavior="rscfd";
        status_register="CFSTS5"; fifo_index=5; fifo_channel=1;
        access_widths="1,2,4";
        field { sw=r; reset=0; } value[31:0];
    } CFDF6_5 @ 0xFFD236A4;

    reg {
        regwidth=32; accesswidth=32; desc="RSCFD0CFDCFDF7_5 (CFID5 window +0x28): CFIFO 5 unread-message data bytes 28..31; read-only in receive mode";
        evidence="manual"; source_ref="R01UH0585EJ0120 section 17.4.8.7, Tables 17.12 and 17.138 (page 1003); SFR list FFD236A8"; behavior="rscfd";
        status_register="CFSTS5"; fifo_index=5; fifo_channel=1;
        access_widths="1,2,4";
        field { sw=r; reset=0; } value[31:0];
    } CFDF7_5 @ 0xFFD236A8;

    reg {
        regwidth=32; accesswidth=32; desc="RSCFD0CFDCFDF8_5 (CFID5 window +0x2C): CFIFO 5 unread-message data bytes 32..35; read-only in receive mode";
        evidence="manual"; source_ref="R01UH0585EJ0120 section 17.4.8.7, Tables 17.12 and 17.138 (page 1003); SFR list FFD236AC"; behavior="rscfd";
        status_register="CFSTS5"; fifo_index=5; fifo_channel=1;
        access_widths="1,2,4";
        field { sw=r; reset=0; } value[31:0];
    } CFDF8_5 @ 0xFFD236AC;

    reg {
        regwidth=32; accesswidth=32; desc="RSCFD0CFDCFDF9_5 (CFID5 window +0x30): CFIFO 5 unread-message data bytes 36..39; read-only in receive mode";
        evidence="manual"; source_ref="R01UH0585EJ0120 section 17.4.8.7, Tables 17.12 and 17.138 (page 1003); SFR list FFD236B0"; behavior="rscfd";
        status_register="CFSTS5"; fifo_index=5; fifo_channel=1;
        access_widths="1,2,4";
        field { sw=r; reset=0; } value[31:0];
    } CFDF9_5 @ 0xFFD236B0;

    reg {
        regwidth=32; accesswidth=32; desc="RSCFD0CFDCFDF10_5 (CFID5 window +0x34): CFIFO 5 unread-message data bytes 40..43; read-only in receive mode";
        evidence="manual"; source_ref="R01UH0585EJ0120 section 17.4.8.7, Tables 17.12 and 17.138 (page 1003); SFR list FFD236B4"; behavior="rscfd";
        status_register="CFSTS5"; fifo_index=5; fifo_channel=1;
        access_widths="1,2,4";
        field { sw=r; reset=0; } value[31:0];
    } CFDF10_5 @ 0xFFD236B4;

    reg {
        regwidth=32; accesswidth=32; desc="RSCFD0CFDCFDF11_5 (CFID5 window +0x38): CFIFO 5 unread-message data bytes 44..47; read-only in receive mode";
        evidence="manual"; source_ref="R01UH0585EJ0120 section 17.4.8.7, Tables 17.12 and 17.138 (page 1003); SFR list FFD236B8"; behavior="rscfd";
        status_register="CFSTS5"; fifo_index=5; fifo_channel=1;
        access_widths="1,2,4";
        field { sw=r; reset=0; } value[31:0];
    } CFDF11_5 @ 0xFFD236B8;

    reg {
        regwidth=32; accesswidth=32; desc="RSCFD0CFDCFDF12_5 (CFID5 window +0x3C): CFIFO 5 unread-message data bytes 48..51; read-only in receive mode";
        evidence="manual"; source_ref="R01UH0585EJ0120 section 17.4.8.7, Tables 17.12 and 17.138 (page 1003); SFR list FFD236BC"; behavior="rscfd";
        status_register="CFSTS5"; fifo_index=5; fifo_channel=1;
        access_widths="1,2,4";
        field { sw=r; reset=0; } value[31:0];
    } CFDF12_5 @ 0xFFD236BC;

    reg {
        regwidth=32; accesswidth=32; desc="RSCFD0CFDCFDF13_5 (CFID5 window +0x40): CFIFO 5 unread-message data bytes 52..55; read-only in receive mode";
        evidence="manual"; source_ref="R01UH0585EJ0120 section 17.4.8.7, Tables 17.12 and 17.138 (page 1003); SFR list FFD236C0"; behavior="rscfd";
        status_register="CFSTS5"; fifo_index=5; fifo_channel=1;
        access_widths="1,2,4";
        field { sw=r; reset=0; } value[31:0];
    } CFDF13_5 @ 0xFFD236C0;

    reg {
        regwidth=32; accesswidth=32; desc="RSCFD0CFDCFDF14_5 (CFID5 window +0x44): CFIFO 5 unread-message data bytes 56..59; read-only in receive mode";
        evidence="manual"; source_ref="R01UH0585EJ0120 section 17.4.8.7, Tables 17.12 and 17.138 (page 1003); SFR list FFD236C4"; behavior="rscfd";
        status_register="CFSTS5"; fifo_index=5; fifo_channel=1;
        access_widths="1,2,4";
        field { sw=r; reset=0; } value[31:0];
    } CFDF14_5 @ 0xFFD236C4;

    reg {
        regwidth=32; accesswidth=32; desc="RSCFD0CFDCFDF15_5 (CFID5 window +0x48): CFIFO 5 unread-message data bytes 60..63; read-only in receive mode";
        evidence="manual"; source_ref="R01UH0585EJ0120 section 17.4.8.7, Tables 17.12 and 17.138 (page 1003); SFR list FFD236C8"; behavior="rscfd";
        status_register="CFSTS5"; fifo_index=5; fifo_channel=1;
        access_widths="1,2,4";
        field { sw=r; reset=0; } value[31:0];
    } CFDF15_5 @ 0xFFD236C8;

    reg {
        regwidth=32; accesswidth=32; desc="RSCFD0CFDGCFG: global configuration; CMPOC bit 5 payload-overflow mode (0 = frame whose payload exceeds storage size is not stored; 1 = stored with excess payload discarded), DRE bit 2 DLC replacement, ITRCP[31:16] interval-timer prescaler, TSBTCS[15:13]/TSSS bit 12/TSP[11:8] timestamp clock; reset 0x0";
        evidence="manual"; source_ref="R01UH0585EJ0120 Table 17.106, section 17.4.4.1 (pages 948-950); SFR list FFD20084"; behavior="rscfd";
        field { sw=rw; reset=0; } value[31:0];
    } GCFG @ 0xFFD20084;

    reg {
        regwidth=32; accesswidth=32; desc="RSCFD0CFDGCTR: global control; GSLPR bit 2 global stop, GMDC[1:0] bits 1-0 (00 global operating, 01 global reset, 10 global test); reset 0x5 (global reset with stop)";
        evidence="manual"; source_ref="R01UH0585EJ0120 Table 17.107, section 17.4.4.2 (page 952); SFR list FFD20088"; behavior="rscfd";
        field { sw=rw; reset=5; } value[31:0];
    } GCTR @ 0xFFD20088;

    reg {
        regwidth=32; accesswidth=32; desc="RSCFD0CFDGSTS: global status; GRAMINIT bit 3, GSLPSTS bit 2, GHLTSTS bit 1, GRSTSTS bit 0; reset 0xD";
        evidence="manual"; source_ref="R01UH0585EJ0120 section 17.4.4.3, Table 17.108 (pages 954-955)"; behavior="rscfd";
        access_widths="1,2,4";
        field { sw=r; reset=13; } value[31:0];
    } GSTS @ 0xFFD2008C;

    reg {
        regwidth=32; accesswidth=32; desc="RSCFD0CFDC1CTR (CmCTR = base+0x04+0x10*m, m=1): CAN1 channel control; CHMDC[1:0] bits 1-0 (00 channel communication, 01 channel reset, 10 channel halt), CSLPR bit 2 channel stop; reset 0x5 (channel reset and stop)";
        evidence="manual"; source_ref="R01UH0585EJ0120 Table 17.96, section 17.4.3.2 (pages 923-925); SFR list FFD20014"; behavior="rscfd";
        field { sw=rw; reset=5; } value[31:0];
    } C1CTR @ 0xFFD20014;

    reg {
        regwidth=32; accesswidth=32; desc="RSCFD0CFDC1STS (CmSTS = base+0x08+0x10*m, m=1): CAN1 channel status; TEC[31:24] and REC[23:16] error counters, ESIF bit 8, COMSTS bit 7, RECSTS bit 6, TRMSTS bit 5, BOSTS bit 4, EPSTS bit 3, CSLPSTS bit 2, CHLTSTS bit 1, CRSTSTS bit 0; reset 0x5 (channel stop + channel reset state); native diagnostic receive gate 0x83EF2 polls (C1STS & 7) == 0 before entering the CFIFO receive path";
        evidence="manual"; source_ref="R01UH0585EJ0120 Tables 17.12 and 17.97, section 17.4.3.3 (pages 797, 928-929); SFR list FFD20018; firmware table 0x22F6C stores this address; native gate 0x83EF2 masks with 7"; behavior="rscfd";
        access_widths="1,2,4";
        field { sw=rw; reset=5; } value[31:0];
    } C1STS @ 0xFFD20018;

    reg {
        regwidth=32; accesswidth=32; desc="RSCFD Tx message-buffer RAM base (0x20-byte entries)";
        evidence="manual"; source_ref="R01UH0585EJ0120 section 17, RSCFD register tables; firmware-observed role"; behavior="rscfd";
        access_widths="1,2,4";
        field { sw=rw; } value[31:0];
    } CFDTMID @ 0xFFD24000;

    reg {
        regwidth=32; accesswidth=32; desc="Diagnostic Tx message RAM for buffer n=16 (CAN 0x7A9 path)";
        evidence="manual"; source_ref="R01UH0585EJ0120 section 17, RSCFD register tables; firmware-observed role"; behavior="rscfd";
        access_widths="1,2,4";
        field { sw=rw; } value[31:0];
    } CFDTMID16 @ 0xFFD24200;

    reg {
        regwidth=32; accesswidth=32; desc="Diagnostic Tx buffer n=16 pointer/DLC word";
        evidence="manual"; source_ref="R01UH0585EJ0120 section 17, RSCFD Tx message-buffer RAM"; behavior="rscfd";
        access_widths="1,2,4";
        field { sw=rw; } value[31:0];
    } CFDTMPTR16 @ 0xFFD24204;

    reg {
        regwidth=32; accesswidth=32; desc="Diagnostic Tx buffer n=16 FD pointer/status word";
        evidence="manual"; source_ref="R01UH0585EJ0120 section 17, RSCFD Tx message-buffer RAM"; behavior="rscfd";
        access_widths="1,2,4";
        field { sw=rw; } value[31:0];
    } CFDTMFDSTS16 @ 0xFFD24208;

    reg {
        regwidth=32; accesswidth=32; desc="Diagnostic Tx buffer n=16 data bytes 0..3";
        evidence="manual"; source_ref="R01UH0585EJ0120 section 17, RSCFD Tx message-buffer RAM"; behavior="rscfd";
        access_widths="1,2,4";
        field { sw=rw; } value[31:0];
    } CFDTMDF0_16 @ 0xFFD2420C;

    reg {
        regwidth=32; accesswidth=32; desc="Diagnostic Tx buffer n=16 data bytes 4..7";
        evidence="manual"; source_ref="R01UH0585EJ0120 section 17, RSCFD Tx message-buffer RAM"; behavior="rscfd";
        access_widths="1,2,4";
        field { sw=rw; } value[31:0];
    } CFDTMDF1_16 @ 0xFFD24210;

    reg {
        regwidth=32; accesswidth=32; desc="Application CAN1 Tx message RAM buffer n=16 identifier";
        evidence="manual"; source_ref="R01UH0585EJ0120 section 17, RSCFD channel-1 Tx message-buffer RAM"; behavior="rscfd";
        access_widths="1,2,4";
        field { sw=rw; } value[31:0];
    } CFDTMID_CH1_16 @ 0xFFD24400;

    reg {
        regwidth=32; accesswidth=32; desc="Application CAN1 Tx message RAM buffer n=16 pointer/DLC word";
        evidence="manual"; source_ref="R01UH0585EJ0120 section 17, RSCFD channel-1 Tx message-buffer RAM"; behavior="rscfd";
        access_widths="1,2,4";
        field { sw=rw; } value[31:0];
    } CFDTMPTR_CH1_16 @ 0xFFD24404;

    reg {
        regwidth=32; accesswidth=32; desc="Application CAN1 Tx buffer n=16 FD pointer/status word";
        evidence="manual"; source_ref="R01UH0585EJ0120 section 17, RSCFD channel-1 Tx message-buffer RAM"; behavior="rscfd";
        access_widths="1,2,4";
        field { sw=rw; } value[31:0];
    } CFDTMFDSTS_CH1_16 @ 0xFFD24408;

    reg {
        regwidth=32; accesswidth=32; desc="Application CAN1 Tx buffer n=16 data bytes 0..3";
        evidence="manual"; source_ref="R01UH0585EJ0120 section 17, RSCFD channel-1 Tx message-buffer RAM"; behavior="rscfd";
        access_widths="1,2,4";
        field { sw=rw; } value[31:0];
    } CFDTMDF0_CH1_16 @ 0xFFD2440C;

    reg {
        regwidth=32; accesswidth=32; desc="Application CAN1 Tx buffer n=16 data bytes 4..7";
        evidence="manual"; source_ref="R01UH0585EJ0120 section 17, RSCFD channel-1 Tx message-buffer RAM"; behavior="rscfd";
        access_widths="1,2,4";
        field { sw=rw; } value[31:0];
    } CFDTMDF1_CH1_16 @ 0xFFD24410;

    reg {
        regwidth=32; accesswidth=32; desc="Application CAN1 Tx message RAM buffer local resource 6 identifier";
        evidence="manual"; source_ref="R01UH0585EJ0120 section 17, RSCFD Tx message-buffer RAM; exact registered-firmware response route";
        behavior="rscfd"; access_widths="1,2,4";
        field { sw=rw; } value[31:0];
    } CFDTMID_CH1_6 @ 0xFFD242C0;

    reg {
        regwidth=32; accesswidth=32; desc="Application CAN1 Tx buffer local resource 6 pointer/DLC word";
        evidence="manual"; source_ref="R01UH0585EJ0120 section 17, RSCFD Tx message-buffer RAM; exact registered-firmware response route";
        behavior="rscfd"; access_widths="1,2,4";
        field { sw=rw; } value[31:0];
    } CFDTMPTR_CH1_6 @ 0xFFD242C4;

    reg {
        regwidth=32; accesswidth=32; desc="Application CAN1 Tx buffer local resource 6 FD pointer/status word";
        evidence="manual"; source_ref="R01UH0585EJ0120 section 17, RSCFD Tx message-buffer RAM; exact registered-firmware response route";
        behavior="rscfd"; access_widths="1,2,4";
        field { sw=rw; } value[31:0];
    } CFDTMFDSTS_CH1_6 @ 0xFFD242C8;

    reg {
        regwidth=32; accesswidth=32; desc="Application CAN1 Tx buffer local resource 6 data bytes 0..3";
        evidence="manual"; source_ref="R01UH0585EJ0120 section 17, RSCFD Tx message-buffer RAM; exact registered-firmware response route";
        behavior="rscfd"; access_widths="1,2,4";
        field { sw=rw; } value[31:0];
    } CFDTMDF0_CH1_6 @ 0xFFD242CC;

    reg {
        regwidth=32; accesswidth=32; desc="Application CAN1 Tx buffer local resource 6 data bytes 4..7";
        evidence="manual"; source_ref="R01UH0585EJ0120 section 17, RSCFD Tx message-buffer RAM; exact registered-firmware response route";
        behavior="rscfd"; access_widths="1,2,4";
        field { sw=rw; } value[31:0];
    } CFDTMDF1_CH1_6 @ 0xFFD242D0;

    reg {
        regwidth=32; accesswidth=32; desc="Application CAN1 Tx message RAM buffer local resource 7 identifier";
        evidence="manual"; source_ref="R01UH0585EJ0120 section 17, RSCFD Tx message-buffer RAM; exact registered-firmware response route";
        behavior="rscfd"; access_widths="1,2,4";
        field { sw=rw; } value[31:0];
    } CFDTMID_CH1_7 @ 0xFFD242E0;

    reg {
        regwidth=32; accesswidth=32; desc="Application CAN1 Tx buffer local resource 7 pointer/DLC word";
        evidence="manual"; source_ref="R01UH0585EJ0120 section 17, RSCFD Tx message-buffer RAM; exact registered-firmware response route";
        behavior="rscfd"; access_widths="1,2,4";
        field { sw=rw; } value[31:0];
    } CFDTMPTR_CH1_7 @ 0xFFD242E4;

    reg {
        regwidth=32; accesswidth=32; desc="Application CAN1 Tx buffer local resource 7 FD pointer/status word";
        evidence="manual"; source_ref="R01UH0585EJ0120 section 17, RSCFD Tx message-buffer RAM; exact registered-firmware response route";
        behavior="rscfd"; access_widths="1,2,4";
        field { sw=rw; } value[31:0];
    } CFDTMFDSTS_CH1_7 @ 0xFFD242E8;

    reg {
        regwidth=32; accesswidth=32; desc="Application CAN1 Tx buffer local resource 7 data bytes 0..3";
        evidence="manual"; source_ref="R01UH0585EJ0120 section 17, RSCFD Tx message-buffer RAM; exact registered-firmware response route";
        behavior="rscfd"; access_widths="1,2,4";
        field { sw=rw; } value[31:0];
    } CFDTMDF0_CH1_7 @ 0xFFD242EC;

    reg {
        regwidth=32; accesswidth=32; desc="Application CAN1 Tx buffer local resource 7 data bytes 4..7";
        evidence="manual"; source_ref="R01UH0585EJ0120 section 17, RSCFD Tx message-buffer RAM; exact registered-firmware response route";
        behavior="rscfd"; access_widths="1,2,4";
        field { sw=rw; } value[31:0];
    } CFDTMDF1_CH1_7 @ 0xFFD242F0;

    reg {
        regwidth=32; accesswidth=32;
        desc="PDMA checker-output error injection; PROT=10 authorizes writes and reads as zero";
        evidence="manual"; source_ref="R01UH0585EJ0120 section31.3.2.3 Table31.145; Table32.9 source2";
        behavior="lockstep"; trigger="pdma-comparator";
        writable_mask=0x3FFFFFFF; protection_mask=0xC0000000; protection_value=0x80000000;
        reset_classes="power-on,system-1-cvm,system-1-pin,system-2,application-1";
        field { sw=rw; reset=0; } value[31:0];
    } PDMA_COMP_CNTRL @ 0xFFC4CA00;

    // Section32.3.5: command A5 / desired / inverted desired / desired.
    // No protected value or status-clear side effect commits before step4.
    reg {
        regwidth=8; accesswidth=8; desc="ECM master protected error-set trigger; asserts internal ERROROUT drive";
        evidence="manual"; source_ref="R01UH0585EJ0120 sections32.3.5,32.4.2"; behavior="ecm";
        reset_classes="power-on,system-1-cvm,system-1-pin,system-2,application-1";
        trigger="ecm-output-set"; read_value=0;
        field { sw=w; reset=0; } value[7:0];
    } ECMMESET @ 0xFFD60000;

    reg {
        regwidth=8; accesswidth=8; desc="ECM master protected error-clear trigger; releases internal drive only without unmasked errors";
        evidence="manual"; source_ref="R01UH0585EJ0120 sections32.3.5,32.4.3"; behavior="ecm";
        reset_classes="power-on,system-1-cvm,system-1-pin,system-2,application-1";
        trigger="ecm-output-clear"; read_value=0;
        field { sw=w; reset=0; } value[7:0];
    } ECMMECLR @ 0xFFD60004;

    reg {
        regwidth=32; accesswidth=32; desc="ECM master error-source status 0";
        evidence="manual"; source_ref="R01UH0585EJ0120 section32.4.4,Table32.14"; behavior="ecm";
        reset_classes="power-on";
        field { sw=r; reset=0; } value[31:0];
    } ECMMESSTR0 @ 0xFFD60008;

    reg {
        regwidth=32; accesswidth=32; desc="ECM master error-source status 1";
        evidence="manual"; source_ref="R01UH0585EJ0120 section32.4.5,Table32.14"; behavior="ecm";
        reset_classes="power-on";
        field { sw=r; reset=0; } value[31:0];
    } ECMMESSTR1 @ 0xFFD6000C;

    reg {
        regwidth=32; accesswidth=32; desc="ECM master error-source status 2; bit31=0 ERROROUT low,1 high";
        evidence="manual"; source_ref="R01UH0585EJ0120 section32.4.6 Table32.20"; behavior="ecm";
        trigger="ecm-bist-status"; reset_classes="power-on";
        reset_mask=0x7FFFFFFF;
        // Bit31 is resolved or explicitly sampled pin feedback, not a reset constant. Field BIST
        // latches bit27 even on success; only the clear trigger clears it.
        field { sw=r; reset=0; } value[31:0];
    } ECMMESSTR2 @ 0xFFD60010;

    reg {
        regwidth=32; accesswidth=32; desc="ECM master protection command; full A5/value/inverse/value protocol";
        evidence="manual"; source_ref="R01UH0585EJ0120 sections32.3.5,32.4.7"; behavior="ecm";
        trigger="ecm-command";
        field { sw=w; } value[31:0];
    } ECMMPCMD0 @ 0xFFD60014;

    reg {
        regwidth=8; accesswidth=8; desc="ECM checker protected error-set trigger; GPIO routing and loopback govern ERROROUT_C feedback";
        evidence="manual"; source_ref="R01UH0585EJ0120 sections32.3.5,32.4.2"; behavior="ecm";
        reset_classes="power-on,system-1-cvm,system-1-pin,system-2,application-1";
        trigger="ecm-output-set"; read_value=0;
        field { sw=w; reset=0; } value[7:0];
    } ECMCESET @ 0xFFD61000;

    reg {
        regwidth=8; accesswidth=8; desc="ECM checker protected error-clear trigger; does not configure P3_11 alternative output or loopback";
        evidence="manual"; source_ref="R01UH0585EJ0120 sections32.3.5,32.4.3"; behavior="ecm";
        reset_classes="power-on,system-1-cvm,system-1-pin,system-2,application-1";
        trigger="ecm-output-clear"; read_value=0;
        field { sw=w; reset=0; } value[7:0];
    } ECMCECLR @ 0xFFD61004;

    reg {
        regwidth=32; accesswidth=32; desc="ECM checker error-source status 0";
        evidence="manual"; source_ref="R01UH0585EJ0120 section32.4.4,Table32.14"; behavior="ecm";
        reset_classes="power-on";
        field { sw=r; reset=0; } value[31:0];
    } ECMCESSTR0 @ 0xFFD61008;

    reg {
        regwidth=32; accesswidth=32; desc="ECM checker error-source status 1";
        evidence="manual"; source_ref="R01UH0585EJ0120 section32.4.5,Table32.14"; behavior="ecm";
        reset_classes="power-on";
        field { sw=r; reset=0; } value[31:0];
    } ECMCESSTR1 @ 0xFFD6100C;

    reg {
        regwidth=32; accesswidth=32; desc="ECM checker error-source status 2; bit31=0 ERROROUT_C low,1 high";
        evidence="manual"; source_ref="R01UH0585EJ0120 section32.4.6 Table32.20"; behavior="ecm";
        trigger="ecm-bist-status"; reset_classes="power-on";
        reset_mask=0x7FFFFFFF;
        field { sw=r; reset=0; } value[31:0];
    } ECMCESSTR2 @ 0xFFD61010;

    reg {
        regwidth=32; accesswidth=32; desc="ECM checker protection command; full A5/value/inverse/value protocol";
        evidence="manual"; source_ref="R01UH0585EJ0120 sections32.3.5,32.4.7"; behavior="ecm";
        trigger="ecm-command";
        field { sw=w; } value[31:0];
    } ECMCPCMD0 @ 0xFFD61014;

    reg {
        regwidth=8; accesswidth=8; desc="ECM protected error-pulse configuration; dynamic timing not modeled";
        evidence="manual"; source_ref="R01UH0585EJ0120 sections32.3.5,32.4.8"; behavior="ecm";
        reset_classes="power-on,system-1-cvm,system-1-pin,system-2,application-1";
        field { sw=rw; reset=0; } value[7:0];
    } ECMEPCFG @ 0xFFD62000;

    reg {
        regwidth=32; accesswidth=32; desc="ECM protected maskable-interrupt configuration 0";
        evidence="manual"; source_ref="R01UH0585EJ0120 sections32.3.5,32.4.9"; behavior="ecm";
        reset_classes="power-on,system-1-cvm,system-1-pin,system-2,application-1";
        field { sw=rw; reset=0; } value[31:0];
    } ECMMICFG0 @ 0xFFD62004;

    reg {
        regwidth=32; accesswidth=32; desc="ECM protected maskable-interrupt configuration 1";
        evidence="manual"; source_ref="R01UH0585EJ0120 sections32.3.5,32.4.10"; behavior="ecm";
        reset_classes="power-on,system-1-cvm,system-1-pin,system-2,application-1";
        field { sw=rw; reset=0; } value[31:0];
    } ECMMICFG1 @ 0xFFD62008;

    reg {
        regwidth=32; accesswidth=32; desc="ECM protected maskable-interrupt configuration 2";
        evidence="manual"; source_ref="R01UH0585EJ0120 sections32.3.5,32.4.11"; behavior="ecm";
        reset_classes="power-on,system-1-cvm,system-1-pin,system-2,application-1";
        field { sw=rw; reset=0; } value[31:0];
    } ECMMICFG2 @ 0xFFD6200C;

    reg {
        regwidth=32; accesswidth=32; desc="ECM protected non-maskable-interrupt configuration 0";
        evidence="manual"; source_ref="R01UH0585EJ0120 sections32.3.5,32.4.12"; behavior="ecm";
        reset_classes="power-on,system-1-cvm,system-1-pin,system-2,application-1";
        field { sw=rw; reset=0; } value[31:0];
    } ECMNMICFG0 @ 0xFFD62010;

    reg {
        regwidth=32; accesswidth=32; desc="ECM protected non-maskable-interrupt configuration 1";
        evidence="manual"; source_ref="R01UH0585EJ0120 sections32.3.5,32.4.13"; behavior="ecm";
        reset_classes="power-on,system-1-cvm,system-1-pin,system-2,application-1";
        field { sw=rw; reset=0; } value[31:0];
    } ECMNMICFG1 @ 0xFFD62014;

    reg {
        regwidth=32; accesswidth=32; desc="ECM protected non-maskable-interrupt configuration 2";
        evidence="manual"; source_ref="R01UH0585EJ0120 sections32.3.5,32.4.14"; behavior="ecm";
        reset_classes="power-on,system-1-cvm,system-1-pin,system-2,application-1";
        field { sw=rw; reset=0; } value[31:0];
    } ECMNMICFG2 @ 0xFFD62018;

    reg {
        regwidth=32; accesswidth=32; desc="ECM protected internal-reset configuration 0";
        evidence="manual"; source_ref="R01UH0585EJ0120 sections32.3.5,32.4.15 Table32.13"; behavior="ecm";
        reset_classes="power-on,system-1-cvm,system-1-pin,system-2,application-1";
        field { sw=rw; reset=1; } value[31:0];
    } ECMIRCFG0 @ 0xFFD6201C;

    reg {
        regwidth=32; accesswidth=32; desc="ECM protected internal-reset configuration 1";
        evidence="manual"; source_ref="R01UH0585EJ0120 sections32.3.5,32.4.16"; behavior="ecm";
        reset_classes="power-on,system-1-cvm,system-1-pin,system-2,application-1";
        field { sw=rw; reset=0; } value[31:0];
    } ECMIRCFG1 @ 0xFFD62020;

    reg {
        regwidth=32; accesswidth=32; desc="ECM protected internal-reset configuration 2";
        evidence="manual"; source_ref="R01UH0585EJ0120 sections32.3.5,32.4.17"; behavior="ecm";
        reset_classes="power-on,system-1-cvm,system-1-pin,system-2,application-1";
        field { sw=rw; reset=0; } value[31:0];
    } ECMIRCFG2 @ 0xFFD62024;

    reg {
        regwidth=32; accesswidth=32; desc="ECM protected error mask 0";
        evidence="manual"; source_ref="R01UH0585EJ0120 sections32.3.5,32.4.18"; behavior="ecm";
        reset_classes="power-on,system-1-cvm,system-1-pin,system-2,application-1";
        field { sw=rw; reset=0; } value[31:0];
    } ECMEMK0 @ 0xFFD62028;

    reg {
        regwidth=32; accesswidth=32; desc="ECM protected error mask 1";
        evidence="manual"; source_ref="R01UH0585EJ0120 sections32.3.5,32.4.19"; behavior="ecm";
        reset_classes="power-on,system-1-cvm,system-1-pin,system-2,application-1";
        field { sw=rw; reset=0; } value[31:0];
    } ECMEMK1 @ 0xFFD6202C;

    reg {
        regwidth=32; accesswidth=32; desc="ECM protected error mask 2";
        evidence="manual"; source_ref="R01UH0585EJ0120 sections32.3.5,32.4.20"; behavior="ecm";
        reset_classes="power-on,system-1-cvm,system-1-pin,system-2,application-1";
        field { sw=rw; reset=0; } value[31:0];
    } ECMEMK2 @ 0xFFD62030;

    reg {
        regwidth=32; accesswidth=32; desc="ECM protected write-one status-clear 0; affects master and checker";
        evidence="manual"; source_ref="R01UH0585EJ0120 sections32.3.5,32.4.21"; behavior="ecm";
        reset_classes="power-on,system-1-cvm,system-1-pin,system-2,application-1";
        trigger="ecm-status-clear";
        field { sw=w; reset=0; } value[31:0];
    } ECMESSTC0 @ 0xFFD62034;

    reg {
        regwidth=32; accesswidth=32; desc="ECM protected write-one status-clear 1; affects master and checker";
        evidence="manual"; source_ref="R01UH0585EJ0120 sections32.3.5,32.4.22"; behavior="ecm";
        reset_classes="power-on,system-1-cvm,system-1-pin,system-2,application-1";
        trigger="ecm-status-clear";
        field { sw=w; reset=0; } value[31:0];
    } ECMESSTC1 @ 0xFFD62038;

    reg {
        regwidth=32; accesswidth=32; desc="ECM protected write-one status-clear 2; preserves external pin bit31";
        evidence="manual"; source_ref="R01UH0585EJ0120 sections32.3.5,32.4.23"; behavior="ecm";
        reset_classes="power-on,system-1-cvm,system-1-pin,system-2,application-1";
        trigger="ecm-status-clear";
        field { sw=w; reset=0; } value[31:0];
    } ECMESSTC2 @ 0xFFD6203C;

    reg {
        regwidth=32; accesswidth=32; desc="ECM common protection command; full A5/value/inverse/value protocol";
        evidence="manual"; source_ref="R01UH0585EJ0120 sections32.3.5,32.4.24"; behavior="ecm";
        trigger="ecm-command";
        field { sw=w; } value[31:0];
    } ECMPCMD1 @ 0xFFD62040;

    // Native ECMPS is 8-bit (manual32.4.25 and vendor DR7F701381.DVF ECM.PS).
    // F33 0x3FE/0x6AA use ld.w. Native CS+ CPU execution at0x3FE with
    // ECM.PS=1 returns00000001. Only that containing-word read is declared;
    // this vendor-simulator observation is not silicon bus-width proof.
    reg {
        regwidth=8; accesswidth=8; access_widths="1,4"; desc="ECM protection status; real failure bit0; declared word read zero-extends native byte";
        evidence="manual+firmware"; source_ref="R01UH0585EJ0120 section32.4.25 Table32.39; DR7F701381.DVF ECM.PS native8; F33 CodeFlash0x3FE/0x6AA ld.w; native CS+ CPU word-read observation";
        behavior="ecm";
        reset_classes="power-on,system-1-cvm,system-1-pin,system-2,application-1";
        field { sw=r; reset=0; } value[7:0];
    } ECMPS @ 0xFFD62044;

    reg {
        regwidth=32; accesswidth=32; desc="ECM protected pseudo-error trigger 0; nonzero error generation is unmodeled";
        evidence="manual"; source_ref="R01UH0585EJ0120 sections32.3.5,32.4.26"; behavior="ecm";
        reset_classes="power-on,system-1-cvm,system-1-pin,system-2,application-1";
        trigger="ecm-pseudo-error";
        field { sw=w; reset=0; } value[31:0];
    } ECMPE0 @ 0xFFD62048;

    reg {
        regwidth=32; accesswidth=32; desc="ECM protected pseudo-error trigger 1; nonzero error generation is unmodeled";
        evidence="manual"; source_ref="R01UH0585EJ0120 sections32.3.5,32.4.27"; behavior="ecm";
        reset_classes="power-on,system-1-cvm,system-1-pin,system-2,application-1";
        trigger="ecm-pseudo-error";
        field { sw=w; reset=0; } value[31:0];
    } ECMPE1 @ 0xFFD6204C;

    reg {
        regwidth=32; accesswidth=32; desc="ECM protected pseudo-error trigger 2; nonzero error generation is unmodeled";
        evidence="manual"; source_ref="R01UH0585EJ0120 sections32.3.5,32.4.28"; behavior="ecm";
        reset_classes="power-on,system-1-cvm,system-1-pin,system-2,application-1";
        trigger="ecm-pseudo-error";
        field { sw=w; reset=0; } value[31:0];
    } ECMPE2 @ 0xFFD62050;

    reg {
        regwidth=8; accesswidth=8; desc="ECM protected delay-timer control; active timer operation is unmodeled";
        evidence="manual"; source_ref="R01UH0585EJ0120 sections32.3.5,32.4.29"; behavior="ecm";
        reset_classes="power-on,system-1-cvm,system-1-pin,system-2,application-1";
        field { sw=rw; reset=0; } value[7:0];
    } ECMDTMCTL @ 0xFFD62054;

    reg {
        regwidth=16; accesswidth=16; desc="ECM delay-timer count";
        evidence="manual"; source_ref="R01UH0585EJ0120 section32.4.30 Table32.13"; behavior="ecm";
        reset_classes="power-on,system-1-cvm,system-1-pin,system-2,application-1";
        field { sw=r; reset=0; } value[15:0];
    } ECMDTMR @ 0xFFD62058;

    reg {
        regwidth=32; accesswidth=32; desc="ECM protected delay-timer compare";
        evidence="manual"; source_ref="R01UH0585EJ0120 sections32.3.5,32.4.31"; behavior="ecm";
        reset_classes="power-on,system-1-cvm,system-1-pin,system-2,application-1";
        field { sw=rw; reset=0; } value[31:0];
    } ECMDTMCMP @ 0xFFD6205C;

    reg {
        regwidth=32; accesswidth=32; desc="ECM protected delay-timer configuration 0";
        evidence="manual"; source_ref="R01UH0585EJ0120 sections32.3.5,32.4.32"; behavior="ecm";
        reset_classes="power-on,system-1-cvm,system-1-pin,system-2,application-1";
        field { sw=rw; reset=0; } value[31:0];
    } ECMDTMCFG0 @ 0xFFD62060;

    reg {
        regwidth=32; accesswidth=32; desc="ECM protected delay-timer configuration 1";
        evidence="manual"; source_ref="R01UH0585EJ0120 sections32.3.5,32.4.33"; behavior="ecm";
        reset_classes="power-on,system-1-cvm,system-1-pin,system-2,application-1";
        field { sw=rw; reset=0; } value[31:0];
    } ECMDTMCFG1 @ 0xFFD62064;

    reg {
        regwidth=32; accesswidth=32; desc="ECM protected delay-timer configuration 2";
        evidence="manual"; source_ref="R01UH0585EJ0120 sections32.3.5,32.4.34"; behavior="ecm";
        reset_classes="power-on,system-1-cvm,system-1-pin,system-2,application-1";
        field { sw=rw; reset=0; } value[31:0];
    } ECMDTMCFG2 @ 0xFFD62068;

    reg {
        regwidth=32; accesswidth=32; desc="ECM protected delay-timer configuration 3";
        evidence="manual"; source_ref="R01UH0585EJ0120 sections32.3.5,32.4.35"; behavior="ecm";
        reset_classes="power-on,system-1-cvm,system-1-pin,system-2,application-1";
        field { sw=rw; reset=0; } value[31:0];
    } ECMDTMCFG3 @ 0xFFD6206C;

    reg {
        regwidth=32; accesswidth=32; desc="ECM protected delay-timer configuration 4";
        evidence="manual"; source_ref="R01UH0585EJ0120 sections32.3.5,32.4.36"; behavior="ecm";
        reset_classes="power-on,system-1-cvm,system-1-pin,system-2,application-1";
        field { sw=rw; reset=0; } value[31:0];
    } ECMDTMCFG4 @ 0xFFD62070;

    reg {
        regwidth=32; accesswidth=32; desc="ECM protected delay-timer configuration 5";
        evidence="manual"; source_ref="R01UH0585EJ0120 sections32.3.5,32.4.37"; behavior="ecm";
        reset_classes="power-on,system-1-cvm,system-1-pin,system-2,application-1";
        field { sw=rw; reset=0; } value[31:0];
    } ECMDTMCFG5 @ 0xFFD62074;

    reg {
        regwidth=32; accesswidth=32; desc="ECM protected error-output clear-invalidation configuration";
        evidence="manual"; source_ref="R01UH0585EJ0120 sections32.3.5,32.4.38"; behavior="ecm";
        reset_classes="power-on,system-1-cvm,system-1-pin,system-2";
        field { sw=rw; reset=0; } value[31:0];
    } ECMEOCCFG @ 0xFFD62078;

    reg {
        regwidth=32; accesswidth=32; desc="ECM pseudo-error mask; unprotected";
        evidence="manual"; source_ref="R01UH0585EJ0120 section32.4.39 Table32.13"; behavior="ecm";
        reset_classes="power-on,system-1-cvm,system-1-pin,system-2,application-1";
        writable_mask=3;
        field { sw=rw; reset=0; } value[31:0];
    } ECMPEM @ 0xFFD6207C;

    reg {
        regwidth=8; accesswidth=8; desc="ECM error-pulse control; unprotected";
        evidence="manual"; source_ref="R01UH0585EJ0120 section32.4.40 Table32.13"; behavior="ecm";
        reset_classes="power-on,system-1-cvm,system-1-pin,system-2,application-1";
        writable_mask=1;
        field { sw=rw; reset=0; } value[7:0];
    } ECMEPCTL @ 0xFFD63000;

    reg taud_rw16_t {
        regwidth=16; accesswidth=16; behavior="taud"; evidence="manual";
        source_ref="R01UH0585EJ0120 section23.3";
        reset_classes="power-on,system-1-cvm,system-1-pin,system-2,application-1";
        writable_mask=0xFFFF;
        field { sw=rw; reset=0; } value[15:0];
    };
    reg taud_count_t {
        regwidth=16; accesswidth=16; behavior="taud"; evidence="manual";
        source_ref="R01UH0585EJ0120 section23.3.3.2";
        reset_classes="power-on,system-1-cvm,system-1-pin,system-2,application-1";
        field { sw=r; reset=0xFFFF; } value[15:0];
    };
    reg taud_rw8_t {
        regwidth=8; accesswidth=8; behavior="taud"; evidence="manual";
        source_ref="R01UH0585EJ0120 section23.3";
        reset_classes="power-on,system-1-cvm,system-1-pin,system-2,application-1";
        writable_mask=0xFF;
        field { sw=rw; reset=0; } value[7:0];
    };
    reg taud_ro16_t {
        regwidth=16; accesswidth=16; behavior="taud"; evidence="manual";
        source_ref="R01UH0585EJ0120 section23.3";
        reset_classes="power-on,system-1-cvm,system-1-pin,system-2,application-1";
        field { sw=r; reset=0; } value[15:0];
    };
    reg taud_status_t {
        regwidth=8; accesswidth=8; behavior="taud"; evidence="manual";
        source_ref="R01UH0585EJ0120 section23.3.3.5";
        reset_classes="power-on,system-1-cvm,system-1-pin,system-2,application-1";
        field { sw=r; reset=0; } value[7:0];
    };
    reg taud_cmd16_t {
        regwidth=16; accesswidth=16; behavior="taud"; evidence="manual";
        source_ref="R01UH0585EJ0120 section23.3"; read_value=0; writable_mask=0xFFFF;
        reset_classes="power-on,system-1-cvm,system-1-pin,system-2,application-1";
        field { sw=w; reset=0; } value[15:0];
    };
    reg taud_clear_t {
        regwidth=8; accesswidth=8; behavior="taud"; evidence="manual";
        source_ref="R01UH0585EJ0120 section23.3.3.6"; read_value=0; writable_mask=1;
        reset_classes="power-on,system-1-cvm,system-1-pin,system-2,application-1";
        field { sw=w; reset=0; } value[7:0];
    };
    reg taud_tps_t {
        regwidth=16; accesswidth=16; behavior="taud"; evidence="manual";
        source_ref="R01UH0585EJ0120 section23.3.2.1"; writable_mask=0xFFFF;
        reset_classes="power-on,system-1-cvm,system-1-pin,system-2,application-1";
        field { sw=rw; reset=0xFFFF; } value[15:0];
    };
    reg taud_pic_t {
        regwidth=16; accesswidth=16; behavior="pic-taud"; evidence="manual";
        source_ref="R01UH0585EJ0120 Table29.45"; writable_mask=0xFFFF;
        reset_classes="power-on,system-1-cvm,system-1-pin,system-2,application-1";
        field { sw=rw; reset=0; } value[15:0];
    };
    taud_rw16_t TAUD0CDR0 @ 0xFFE20000; taud_rw16_t TAUD0CDR1 @ 0xFFE20004;
    taud_rw16_t TAUD0CDR2 @ 0xFFE20008; taud_rw16_t TAUD0CDR3 @ 0xFFE2000C;
    taud_rw16_t TAUD0CDR4 @ 0xFFE20010; taud_rw16_t TAUD0CDR5 @ 0xFFE20014;
    taud_rw16_t TAUD0CDR6 @ 0xFFE20018; taud_rw16_t TAUD0CDR7 @ 0xFFE2001C;
    taud_rw16_t TAUD0CDR8 @ 0xFFE20020; taud_rw16_t TAUD0CDR9 @ 0xFFE20024;
    taud_rw16_t TAUD0CDR10 @ 0xFFE20028; taud_rw16_t TAUD0CDR11 @ 0xFFE2002C;
    taud_rw16_t TAUD0CDR12 @ 0xFFE20030; taud_rw16_t TAUD0CDR13 @ 0xFFE20034;
    taud_rw16_t TAUD0CDR14 @ 0xFFE20038; taud_rw16_t TAUD0CDR15 @ 0xFFE2003C;
    taud_count_t TAUD0CNT0 @ 0xFFE20080; taud_count_t TAUD0CNT1 @ 0xFFE20084;
    taud_count_t TAUD0CNT2 @ 0xFFE20088; taud_count_t TAUD0CNT3 @ 0xFFE2008C;
    taud_count_t TAUD0CNT4 @ 0xFFE20090; taud_count_t TAUD0CNT5 @ 0xFFE20094;
    taud_count_t TAUD0CNT6 @ 0xFFE20098; taud_count_t TAUD0CNT7 @ 0xFFE2009C;
    taud_count_t TAUD0CNT8 @ 0xFFE200A0; taud_count_t TAUD0CNT9 @ 0xFFE200A4;
    taud_count_t TAUD0CNT10 @ 0xFFE200A8; taud_count_t TAUD0CNT11 @ 0xFFE200AC;
    taud_count_t TAUD0CNT12 @ 0xFFE200B0; taud_count_t TAUD0CNT13 @ 0xFFE200B4;
    taud_count_t TAUD0CNT14 @ 0xFFE200B8; taud_count_t TAUD0CNT15 @ 0xFFE200BC;
    taud_rw8_t TAUD0CMUR0 @ 0xFFE200C0; TAUD0CMUR0->writable_mask=3;
    taud_rw8_t TAUD0CMUR1 @ 0xFFE200C4; TAUD0CMUR1->writable_mask=3;
    taud_rw8_t TAUD0CMUR2 @ 0xFFE200C8; TAUD0CMUR2->writable_mask=3;
    taud_rw8_t TAUD0CMUR3 @ 0xFFE200CC; TAUD0CMUR3->writable_mask=3;
    taud_rw8_t TAUD0CMUR4 @ 0xFFE200D0; TAUD0CMUR4->writable_mask=3;
    taud_rw8_t TAUD0CMUR5 @ 0xFFE200D4; TAUD0CMUR5->writable_mask=3;
    taud_rw8_t TAUD0CMUR6 @ 0xFFE200D8; TAUD0CMUR6->writable_mask=3;
    taud_rw8_t TAUD0CMUR7 @ 0xFFE200DC; TAUD0CMUR7->writable_mask=3;
    taud_rw8_t TAUD0CMUR8 @ 0xFFE200E0; TAUD0CMUR8->writable_mask=3;
    taud_rw8_t TAUD0CMUR9 @ 0xFFE200E4; TAUD0CMUR9->writable_mask=3;
    taud_rw8_t TAUD0CMUR10 @ 0xFFE200E8; TAUD0CMUR10->writable_mask=3;
    taud_rw8_t TAUD0CMUR11 @ 0xFFE200EC; TAUD0CMUR11->writable_mask=3;
    taud_rw8_t TAUD0CMUR12 @ 0xFFE200F0; TAUD0CMUR12->writable_mask=3;
    taud_rw8_t TAUD0CMUR13 @ 0xFFE200F4; TAUD0CMUR13->writable_mask=3;
    taud_rw8_t TAUD0CMUR14 @ 0xFFE200F8; TAUD0CMUR14->writable_mask=3;
    taud_rw8_t TAUD0CMUR15 @ 0xFFE200FC; TAUD0CMUR15->writable_mask=3;
    taud_status_t TAUD0CSR0 @ 0xFFE20140; taud_status_t TAUD0CSR1 @ 0xFFE20144;
    taud_status_t TAUD0CSR2 @ 0xFFE20148; taud_status_t TAUD0CSR3 @ 0xFFE2014C;
    taud_status_t TAUD0CSR4 @ 0xFFE20150; taud_status_t TAUD0CSR5 @ 0xFFE20154;
    taud_status_t TAUD0CSR6 @ 0xFFE20158; taud_status_t TAUD0CSR7 @ 0xFFE2015C;
    taud_status_t TAUD0CSR8 @ 0xFFE20160; taud_status_t TAUD0CSR9 @ 0xFFE20164;
    taud_status_t TAUD0CSR10 @ 0xFFE20168; taud_status_t TAUD0CSR11 @ 0xFFE2016C;
    taud_status_t TAUD0CSR12 @ 0xFFE20170; taud_status_t TAUD0CSR13 @ 0xFFE20174;
    taud_status_t TAUD0CSR14 @ 0xFFE20178; taud_status_t TAUD0CSR15 @ 0xFFE2017C;
    taud_clear_t TAUD0CSC0 @ 0xFFE20180; taud_clear_t TAUD0CSC1 @ 0xFFE20184;
    taud_clear_t TAUD0CSC2 @ 0xFFE20188; taud_clear_t TAUD0CSC3 @ 0xFFE2018C;
    taud_clear_t TAUD0CSC4 @ 0xFFE20190; taud_clear_t TAUD0CSC5 @ 0xFFE20194;
    taud_clear_t TAUD0CSC6 @ 0xFFE20198; taud_clear_t TAUD0CSC7 @ 0xFFE2019C;
    taud_clear_t TAUD0CSC8 @ 0xFFE201A0; taud_clear_t TAUD0CSC9 @ 0xFFE201A4;
    taud_clear_t TAUD0CSC10 @ 0xFFE201A8; taud_clear_t TAUD0CSC11 @ 0xFFE201AC;
    taud_clear_t TAUD0CSC12 @ 0xFFE201B0; taud_clear_t TAUD0CSC13 @ 0xFFE201B4;
    taud_clear_t TAUD0CSC14 @ 0xFFE201B8; taud_clear_t TAUD0CSC15 @ 0xFFE201BC;
    taud_rw16_t TAUD0CMOR0 @ 0xFFE20200; taud_rw16_t TAUD0CMOR1 @ 0xFFE20204;
    taud_rw16_t TAUD0CMOR2 @ 0xFFE20208; taud_rw16_t TAUD0CMOR3 @ 0xFFE2020C;
    taud_rw16_t TAUD0CMOR4 @ 0xFFE20210; taud_rw16_t TAUD0CMOR5 @ 0xFFE20214;
    taud_rw16_t TAUD0CMOR6 @ 0xFFE20218; taud_rw16_t TAUD0CMOR7 @ 0xFFE2021C;
    taud_rw16_t TAUD0CMOR8 @ 0xFFE20220; taud_rw16_t TAUD0CMOR9 @ 0xFFE20224;
    taud_rw16_t TAUD0CMOR10 @ 0xFFE20228; taud_rw16_t TAUD0CMOR11 @ 0xFFE2022C;
    taud_rw16_t TAUD0CMOR12 @ 0xFFE20230; taud_rw16_t TAUD0CMOR13 @ 0xFFE20234;
    taud_rw16_t TAUD0CMOR14 @ 0xFFE20238; taud_rw16_t TAUD0CMOR15 @ 0xFFE2023C;
    taud_rw16_t TAUD0TOL @ 0xFFE20040; taud_cmd16_t TAUD0RDT @ 0xFFE20044;
    taud_ro16_t TAUD0RSF @ 0xFFE20048; taud_rw16_t TAUD0TRO @ 0xFFE2004C;
    taud_rw16_t TAUD0TME @ 0xFFE20050; taud_rw16_t TAUD0TDL @ 0xFFE20054;
    taud_rw16_t TAUD0TO @ 0xFFE20058; taud_rw16_t TAUD0TOE @ 0xFFE2005C;
    taud_ro16_t TAUD0TE @ 0xFFE201C0; taud_cmd16_t TAUD0TS @ 0xFFE201C4;
    taud_cmd16_t TAUD0TT @ 0xFFE201C8; taud_tps_t TAUD0TPS @ 0xFFE20240;
    taud_rw8_t TAUD0BRS @ 0xFFE20244;
    taud_rw16_t TAUD0TOM @ 0xFFE20248; taud_rw16_t TAUD0TOC @ 0xFFE2024C;
    taud_rw16_t TAUD0TDE @ 0xFFE20250; taud_rw16_t TAUD0TDM @ 0xFFE20254;
    taud_rw16_t TAUD0TRE @ 0xFFE20258; taud_rw16_t TAUD0TRC @ 0xFFE2025C;
    taud_rw16_t TAUD0RDE @ 0xFFE20260; taud_rw16_t TAUD0RDM @ 0xFFE20264;
    taud_rw16_t TAUD0RDS @ 0xFFE20268; taud_rw16_t TAUD0RDC @ 0xFFE2026C;
    taud_rw16_t TAUD1CDR0 @ 0xFFE21000; taud_rw16_t TAUD1CDR1 @ 0xFFE21004;
    taud_rw16_t TAUD1CDR2 @ 0xFFE21008; taud_rw16_t TAUD1CDR3 @ 0xFFE2100C;
    taud_rw16_t TAUD1CDR4 @ 0xFFE21010; taud_rw16_t TAUD1CDR5 @ 0xFFE21014;
    taud_rw16_t TAUD1CDR6 @ 0xFFE21018; taud_rw16_t TAUD1CDR7 @ 0xFFE2101C;
    taud_rw16_t TAUD1CDR8 @ 0xFFE21020; taud_rw16_t TAUD1CDR9 @ 0xFFE21024;
    taud_rw16_t TAUD1CDR10 @ 0xFFE21028; taud_rw16_t TAUD1CDR11 @ 0xFFE2102C;
    taud_rw16_t TAUD1CDR12 @ 0xFFE21030; taud_rw16_t TAUD1CDR13 @ 0xFFE21034;
    taud_rw16_t TAUD1CDR14 @ 0xFFE21038; taud_rw16_t TAUD1CDR15 @ 0xFFE2103C;
    taud_count_t TAUD1CNT0 @ 0xFFE21080; taud_count_t TAUD1CNT1 @ 0xFFE21084;
    taud_count_t TAUD1CNT2 @ 0xFFE21088; taud_count_t TAUD1CNT3 @ 0xFFE2108C;
    taud_count_t TAUD1CNT4 @ 0xFFE21090; taud_count_t TAUD1CNT5 @ 0xFFE21094;
    taud_count_t TAUD1CNT6 @ 0xFFE21098; taud_count_t TAUD1CNT7 @ 0xFFE2109C;
    taud_count_t TAUD1CNT8 @ 0xFFE210A0; taud_count_t TAUD1CNT9 @ 0xFFE210A4;
    taud_count_t TAUD1CNT10 @ 0xFFE210A8; taud_count_t TAUD1CNT11 @ 0xFFE210AC;
    taud_count_t TAUD1CNT12 @ 0xFFE210B0; taud_count_t TAUD1CNT13 @ 0xFFE210B4;
    taud_count_t TAUD1CNT14 @ 0xFFE210B8; taud_count_t TAUD1CNT15 @ 0xFFE210BC;
    taud_rw8_t TAUD1CMUR0 @ 0xFFE210C0; TAUD1CMUR0->writable_mask=3;
    taud_rw8_t TAUD1CMUR1 @ 0xFFE210C4; TAUD1CMUR1->writable_mask=3;
    taud_rw8_t TAUD1CMUR2 @ 0xFFE210C8; TAUD1CMUR2->writable_mask=3;
    taud_rw8_t TAUD1CMUR3 @ 0xFFE210CC; TAUD1CMUR3->writable_mask=3;
    taud_rw8_t TAUD1CMUR4 @ 0xFFE210D0; TAUD1CMUR4->writable_mask=3;
    taud_rw8_t TAUD1CMUR5 @ 0xFFE210D4; TAUD1CMUR5->writable_mask=3;
    taud_rw8_t TAUD1CMUR6 @ 0xFFE210D8; TAUD1CMUR6->writable_mask=3;
    taud_rw8_t TAUD1CMUR7 @ 0xFFE210DC; TAUD1CMUR7->writable_mask=3;
    taud_rw8_t TAUD1CMUR8 @ 0xFFE210E0; TAUD1CMUR8->writable_mask=3;
    taud_rw8_t TAUD1CMUR9 @ 0xFFE210E4; TAUD1CMUR9->writable_mask=3;
    taud_rw8_t TAUD1CMUR10 @ 0xFFE210E8; TAUD1CMUR10->writable_mask=3;
    taud_rw8_t TAUD1CMUR11 @ 0xFFE210EC; TAUD1CMUR11->writable_mask=3;
    taud_rw8_t TAUD1CMUR12 @ 0xFFE210F0; TAUD1CMUR12->writable_mask=3;
    taud_rw8_t TAUD1CMUR13 @ 0xFFE210F4; TAUD1CMUR13->writable_mask=3;
    taud_rw8_t TAUD1CMUR14 @ 0xFFE210F8; TAUD1CMUR14->writable_mask=3;
    taud_rw8_t TAUD1CMUR15 @ 0xFFE210FC; TAUD1CMUR15->writable_mask=3;
    taud_status_t TAUD1CSR0 @ 0xFFE21140; taud_status_t TAUD1CSR1 @ 0xFFE21144;
    taud_status_t TAUD1CSR2 @ 0xFFE21148; taud_status_t TAUD1CSR3 @ 0xFFE2114C;
    taud_status_t TAUD1CSR4 @ 0xFFE21150; taud_status_t TAUD1CSR5 @ 0xFFE21154;
    taud_status_t TAUD1CSR6 @ 0xFFE21158; taud_status_t TAUD1CSR7 @ 0xFFE2115C;
    taud_status_t TAUD1CSR8 @ 0xFFE21160; taud_status_t TAUD1CSR9 @ 0xFFE21164;
    taud_status_t TAUD1CSR10 @ 0xFFE21168; taud_status_t TAUD1CSR11 @ 0xFFE2116C;
    taud_status_t TAUD1CSR12 @ 0xFFE21170; taud_status_t TAUD1CSR13 @ 0xFFE21174;
    taud_status_t TAUD1CSR14 @ 0xFFE21178; taud_status_t TAUD1CSR15 @ 0xFFE2117C;
    taud_clear_t TAUD1CSC0 @ 0xFFE21180; taud_clear_t TAUD1CSC1 @ 0xFFE21184;
    taud_clear_t TAUD1CSC2 @ 0xFFE21188; taud_clear_t TAUD1CSC3 @ 0xFFE2118C;
    taud_clear_t TAUD1CSC4 @ 0xFFE21190; taud_clear_t TAUD1CSC5 @ 0xFFE21194;
    taud_clear_t TAUD1CSC6 @ 0xFFE21198; taud_clear_t TAUD1CSC7 @ 0xFFE2119C;
    taud_clear_t TAUD1CSC8 @ 0xFFE211A0; taud_clear_t TAUD1CSC9 @ 0xFFE211A4;
    taud_clear_t TAUD1CSC10 @ 0xFFE211A8; taud_clear_t TAUD1CSC11 @ 0xFFE211AC;
    taud_clear_t TAUD1CSC12 @ 0xFFE211B0; taud_clear_t TAUD1CSC13 @ 0xFFE211B4;
    taud_clear_t TAUD1CSC14 @ 0xFFE211B8; taud_clear_t TAUD1CSC15 @ 0xFFE211BC;
    taud_rw16_t TAUD1CMOR0 @ 0xFFE21200; taud_rw16_t TAUD1CMOR1 @ 0xFFE21204;
    taud_rw16_t TAUD1CMOR2 @ 0xFFE21208; taud_rw16_t TAUD1CMOR3 @ 0xFFE2120C;
    taud_rw16_t TAUD1CMOR4 @ 0xFFE21210; taud_rw16_t TAUD1CMOR5 @ 0xFFE21214;
    taud_rw16_t TAUD1CMOR6 @ 0xFFE21218; taud_rw16_t TAUD1CMOR7 @ 0xFFE2121C;
    taud_rw16_t TAUD1CMOR8 @ 0xFFE21220; taud_rw16_t TAUD1CMOR9 @ 0xFFE21224;
    taud_rw16_t TAUD1CMOR10 @ 0xFFE21228; taud_rw16_t TAUD1CMOR11 @ 0xFFE2122C;
    taud_rw16_t TAUD1CMOR12 @ 0xFFE21230; taud_rw16_t TAUD1CMOR13 @ 0xFFE21234;
    taud_rw16_t TAUD1CMOR14 @ 0xFFE21238; taud_rw16_t TAUD1CMOR15 @ 0xFFE2123C;
    taud_rw16_t TAUD1TOL @ 0xFFE21040; taud_cmd16_t TAUD1RDT @ 0xFFE21044;
    taud_ro16_t TAUD1RSF @ 0xFFE21048; taud_rw16_t TAUD1TRO @ 0xFFE2104C;
    taud_rw16_t TAUD1TME @ 0xFFE21050; taud_rw16_t TAUD1TDL @ 0xFFE21054;
    taud_rw16_t TAUD1TO @ 0xFFE21058; taud_rw16_t TAUD1TOE @ 0xFFE2105C;
    taud_ro16_t TAUD1TE @ 0xFFE211C0; taud_cmd16_t TAUD1TS @ 0xFFE211C4;
    taud_cmd16_t TAUD1TT @ 0xFFE211C8; taud_tps_t TAUD1TPS @ 0xFFE21240;
    taud_rw8_t TAUD1BRS @ 0xFFE21244;
    taud_rw16_t TAUD1TOM @ 0xFFE21248; taud_rw16_t TAUD1TOC @ 0xFFE2124C;
    taud_rw16_t TAUD1TDE @ 0xFFE21250; taud_rw16_t TAUD1TDM @ 0xFFE21254;
    taud_rw16_t TAUD1TRE @ 0xFFE21258; taud_rw16_t TAUD1TRC @ 0xFFE2125C;
    taud_rw16_t TAUD1RDE @ 0xFFE21260; taud_rw16_t TAUD1RDM @ 0xFFE21264;
    taud_rw16_t TAUD1RDS @ 0xFFE21268; taud_rw16_t TAUD1RDC @ 0xFFE2126C;
    taud_pic_t PIC2BADTEN400 @ 0xFFDD1040; taud_pic_t PIC2BADTEN401 @ 0xFFDD1044;
    taud_pic_t PIC2BADTEN402 @ 0xFFDD1048; taud_pic_t PIC2BADTEN403 @ 0xFFDD104C;
    taud_pic_t PIC2BADTEN404 @ 0xFFDD1050; taud_pic_t PIC2BADTEN410 @ 0xFFDD1060;
    taud_pic_t PIC2BADTEN411 @ 0xFFDD1064; taud_pic_t PIC2BADTEN412 @ 0xFFDD1068;
    taud_pic_t PIC2BADTEN413 @ 0xFFDD106C; taud_pic_t PIC2BADTEN414 @ 0xFFDD1070;
    reg tauj_data32_t {
        regwidth=32; accesswidth=32; behavior="tauj"; writable_mask=0xFFFFFFFF;
        desc="TAUJ interval reload data; writes do not replace the active counter";
        evidence="manual"; source_ref="R01UH0585EJ0120 Tables24.10,24.13; section24.12.1; AppendixA TAUJ";
        reset_classes="power-on,system-1-cvm,system-1-pin,system-2,application-1";
        field { sw=rw; reset=0; } value[31:0];
    };
    reg tauj_counter32_t {
        regwidth=32; accesswidth=32; behavior="tauj"; writable_mask=0;
        desc="TAUJ current interval counter; stop retains value";
        evidence="manual"; source_ref="R01UH0585EJ0120 Tables24.14,24.15; AppendixA TAUJ";
        reset_classes="power-on,system-1-cvm,system-1-pin,system-2,application-1";
        field { sw=r; reset=0xFFFFFFFF; } value[31:0];
    };
    reg tauj_user8_t {
        regwidth=8; accesswidth=8; behavior="tauj"; writable_mask=0x3;
        desc="TAUJ channel input-edge selection; independent interval operation uses zero";
        evidence="manual"; source_ref="R01UH0585EJ0120 Tables24.17,24.35; AppendixA TAUJ";
        reset_classes="power-on,system-1-cvm,system-1-pin,system-2,application-1";
        field { sw=rw; reset=0; } value[7:0];
    };
    reg tauj_mode16_t {
        regwidth=16; accesswidth=16; behavior="tauj"; writable_mask=0xFFDF;
        desc="TAUJ channel mode; interval controller supports CKS and MD0";
        evidence="manual"; source_ref="R01UH0585EJ0120 Tables24.16,24.34; AppendixA TAUJ";
        reset_classes="power-on,system-1-cvm,system-1-pin,system-2,application-1";
        field { sw=rw; reset=0; } value[15:0];
    };
    reg tauj_status8_t {
        regwidth=8; accesswidth=8; behavior="tauj"; writable_mask=0;
        desc="TAUJ channel status mask, low four bits";
        evidence="manual"; source_ref="R01UH0585EJ0120 Tables24.21,24.26; AppendixA TAUJ";
        reset_classes="power-on,system-1-cvm,system-1-pin,system-2,application-1";
        field { sw=r; reset=0; } value[7:0];
    };
    reg tauj_mask8_t {
        regwidth=8; accesswidth=8; behavior="tauj"; writable_mask=0xF;
        desc="TAUJ per-channel output/reload configuration, low four bits";
        evidence="manual"; source_ref="R01UH0585EJ0120 Tables24.23,24.24,24.27-24.31; AppendixA TAUJ";
        reset_classes="power-on,system-1-cvm,system-1-pin,system-2,application-1";
        field { sw=rw; reset=0; } value[7:0];
    };
    reg tauj_command8_t {
        regwidth=8; accesswidth=8; behavior="tauj"; writable_mask=0xF; read_value=0;
        desc="TAUJ per-channel write-one trigger; always reads zero";
        evidence="manual"; source_ref="R01UH0585EJ0120 Tables24.20,24.22,24.25; AppendixA TAUJ";
        reset_classes="power-on,system-1-cvm,system-1-pin,system-2,application-1";
        field { sw=w; reset=0; } value[7:0];
    };
    reg tauj_prescaler16_t {
        regwidth=16; accesswidth=16; behavior="tauj"; writable_mask=0xFFFF;
        desc="TAUJ shared prescaler CK0..CK3_PRE power-of-two selectors";
        evidence="manual"; source_ref="R01UH0585EJ0120 Table24.11; AppendixA TAUJ";
        reset_classes="power-on,system-1-cvm,system-1-pin,system-2,application-1";
        field { sw=rw; reset=0xFFFF; } value[15:0];
    };
    reg tauj_brg8_t {
        regwidth=8; accesswidth=8; behavior="tauj"; writable_mask=0xFF;
        desc="TAUJ native BYTE baud-rate divider; CK3=CK3_PRE/(BRS+1)";
        evidence="manual"; source_ref="R01UH0585EJ0120 Table24.12; AppendixA TAUJ";
        reset_classes="power-on,system-1-cvm,system-1-pin,system-2,application-1";
        field { sw=rw; reset=0; } value[7:0];
    };

    tauj_data32_t TAUJ0CDR0 @ 0xFFE50000;
    tauj_data32_t TAUJ0CDR1 @ 0xFFE50004;
    tauj_data32_t TAUJ0CDR2 @ 0xFFE50008;
    tauj_data32_t TAUJ0CDR3 @ 0xFFE5000C;
    tauj_counter32_t TAUJ0CNT0 @ 0xFFE50010;
    tauj_counter32_t TAUJ0CNT1 @ 0xFFE50014;
    tauj_counter32_t TAUJ0CNT2 @ 0xFFE50018;
    tauj_counter32_t TAUJ0CNT3 @ 0xFFE5001C;
    tauj_user8_t TAUJ0CMUR0 @ 0xFFE50020;
    tauj_user8_t TAUJ0CMUR1 @ 0xFFE50024;
    tauj_user8_t TAUJ0CMUR2 @ 0xFFE50028;
    tauj_user8_t TAUJ0CMUR3 @ 0xFFE5002C;
    tauj_status8_t TAUJ0TE @ 0xFFE50050;
    tauj_command8_t TAUJ0TS @ 0xFFE50054;
    tauj_command8_t TAUJ0TT @ 0xFFE50058;
    tauj_mask8_t TAUJ0TO @ 0xFFE5005C;
    tauj_mask8_t TAUJ0TOE @ 0xFFE50060;
    tauj_mask8_t TAUJ0TOL @ 0xFFE50064;
    tauj_command8_t TAUJ0RDT @ 0xFFE50068;
    tauj_status8_t TAUJ0RSF @ 0xFFE5006C;
    tauj_mode16_t TAUJ0CMOR0 @ 0xFFE50080;
    tauj_mode16_t TAUJ0CMOR1 @ 0xFFE50084;
    tauj_mode16_t TAUJ0CMOR2 @ 0xFFE50088;
    tauj_mode16_t TAUJ0CMOR3 @ 0xFFE5008C;
    tauj_prescaler16_t TAUJ0TPS @ 0xFFE50090;
    tauj_brg8_t TAUJ0BRS @ 0xFFE50094;
    tauj_mask8_t TAUJ0TOM @ 0xFFE50098;
    tauj_mask8_t TAUJ0TOC @ 0xFFE5009C;
    tauj_mask8_t TAUJ0RDE @ 0xFFE500A0;
    tauj_mask8_t TAUJ0RDM @ 0xFFE500A4;

    tauj_data32_t TAUJ1CDR0 @ 0xFFE51000;
    tauj_data32_t TAUJ1CDR1 @ 0xFFE51004;
    tauj_data32_t TAUJ1CDR2 @ 0xFFE51008;
    tauj_data32_t TAUJ1CDR3 @ 0xFFE5100C;
    tauj_counter32_t TAUJ1CNT0 @ 0xFFE51010;
    tauj_counter32_t TAUJ1CNT1 @ 0xFFE51014;
    tauj_counter32_t TAUJ1CNT2 @ 0xFFE51018;
    tauj_counter32_t TAUJ1CNT3 @ 0xFFE5101C;
    tauj_user8_t TAUJ1CMUR0 @ 0xFFE51020;
    tauj_user8_t TAUJ1CMUR1 @ 0xFFE51024;
    tauj_user8_t TAUJ1CMUR2 @ 0xFFE51028;
    tauj_user8_t TAUJ1CMUR3 @ 0xFFE5102C;
    tauj_status8_t TAUJ1TE @ 0xFFE51050;
    tauj_command8_t TAUJ1TS @ 0xFFE51054;
    tauj_command8_t TAUJ1TT @ 0xFFE51058;
    tauj_mask8_t TAUJ1TO @ 0xFFE5105C;
    tauj_mask8_t TAUJ1TOE @ 0xFFE51060;
    tauj_mask8_t TAUJ1TOL @ 0xFFE51064;
    tauj_command8_t TAUJ1RDT @ 0xFFE51068;
    tauj_status8_t TAUJ1RSF @ 0xFFE5106C;
    tauj_mode16_t TAUJ1CMOR0 @ 0xFFE51080;
    tauj_mode16_t TAUJ1CMOR1 @ 0xFFE51084;
    tauj_mode16_t TAUJ1CMOR2 @ 0xFFE51088;
    tauj_mode16_t TAUJ1CMOR3 @ 0xFFE5108C;
    tauj_prescaler16_t TAUJ1TPS @ 0xFFE51090;
    tauj_brg8_t TAUJ1BRS @ 0xFFE51094;
    tauj_mask8_t TAUJ1TOM @ 0xFFE51098;
    tauj_mask8_t TAUJ1TOC @ 0xFFE5109C;
    tauj_mask8_t TAUJ1RDE @ 0xFFE510A0;
    tauj_mask8_t TAUJ1RDM @ 0xFFE510A4;

    reg {
        regwidth=8; accesswidth=8; behavior="pic1-start"; writable_mask=1; read_value=0;
        desc="PIC1 simultaneous start command; bit0 generates one selected start pulse, reads zero";
        evidence="manual"; source_ref="R01UH0585EJ0120 Table29.11; section29.2.3.1; AppendixA PIC1A";
        reset_classes="power-on,system-1-cvm,system-1-pin,system-2,application-1";
        field { sw=rw; reset=0; } value[7:0];
    } PIC1ASST @ 0xFFDD0004;
    reg pic1_sser16_t {
        regwidth=16; accesswidth=16; behavior="pic1-start"; writable_mask=0xFFFF;
        desc="PIC1 per-channel simultaneous-start enable selector";
        evidence="manual"; source_ref="R01UH0585EJ0120 Tables29.12-29.15; AppendixA PIC1A";
        reset_classes="power-on,system-1-cvm,system-1-pin,system-2,application-1";
        field { sw=rw; reset=0; } value[15:0];
    };
    pic1_sser16_t PIC1ASSER0 @ 0xFFDD0010;
    pic1_sser16_t PIC1ASSER1 @ 0xFFDD0014;
    pic1_sser16_t PIC1ASSER2 @ 0xFFDD0018;
    PIC1ASSER2->writable_mask=0x3FFF;
    pic1_sser16_t PIC1ASSER3 @ 0xFFDD001C;
    PIC1ASSER3->writable_mask=0x3;

    reg {
        regwidth=16; accesswidth=16; desc="TSG30IOC2";
        evidence="manual"; source_ref="R01UH0585EJ0120 section25.3; AppendixA TSG30/31"; behavior="tsg";
        writable_mask=0x7E7E; reset_classes="power-on,system-1-cvm,system-1-pin,system-2,application-1";
        field { sw=rw; reset=0x0; } value[15:0];
    } TSG30IOC2 @ 0xFFE70000;

    reg {
        regwidth=8; accesswidth=8; desc="TSG30CTL3";
        evidence="manual"; source_ref="R01UH0585EJ0120 section25.3; AppendixA TSG30/31"; behavior="tsg";
        writable_mask=0x3; reset_classes="power-on,system-1-cvm,system-1-pin,system-2,application-1";
        field { sw=rw; reset=0x0; } value[7:0];
    } TSG30CTL3 @ 0xFFE70004;

    reg {
        regwidth=16; accesswidth=16; desc="TSG30CTL5";
        evidence="manual"; source_ref="R01UH0585EJ0120 section25.3; AppendixA TSG30/31"; behavior="tsg";
        writable_mask=0xFFF; reset_classes="power-on,system-1-cvm,system-1-pin,system-2,application-1";
        field { sw=rw; reset=0x0; } value[15:0];
    } TSG30CTL5 @ 0xFFE70008;

    reg {
        regwidth=16; accesswidth=16; desc="TSG30CTL6";
        evidence="manual"; source_ref="R01UH0585EJ0120 section25.3; AppendixA TSG30/31"; behavior="tsg";
        writable_mask=0xFFF; reset_classes="power-on,system-1-cvm,system-1-pin,system-2,application-1";
        field { sw=rw; reset=0x0; } value[15:0];
    } TSG30CTL6 @ 0xFFE7000C;

    reg {
        regwidth=8; accesswidth=8; desc="TSG30STR0";
        evidence="manual"; source_ref="R01UH0585EJ0120 section25.3; AppendixA TSG30/31"; behavior="tsg";
        writable_mask=0x0; reset_classes="power-on,system-1-cvm,system-1-pin,system-2,application-1";
        field { sw=r; reset=0x0; } value[7:0];
    } TSG30STR0 @ 0xFFE70010;

    reg {
        regwidth=8; accesswidth=8; desc="TSG30STR1";
        evidence="manual"; source_ref="R01UH0585EJ0120 section25.3; AppendixA TSG30/31"; behavior="tsg";
        writable_mask=0x0; reset_classes="power-on,system-1-cvm,system-1-pin,system-2,application-1";
        field { sw=r; reset=0x0; } value[7:0];
    } TSG30STR1 @ 0xFFE70014;

    reg {
        regwidth=16; accesswidth=16; desc="TSG30STR2";
        evidence="manual"; source_ref="R01UH0585EJ0120 section25.3; AppendixA TSG30/31"; behavior="tsg";
        writable_mask=0x0; reset_classes="power-on,system-1-cvm,system-1-pin,system-2,application-1";
        field { sw=r; reset=0x0; } value[15:0];
    } TSG30STR2 @ 0xFFE70018;

    reg {
        regwidth=16; accesswidth=16; desc="TSG30STC";
        evidence="manual"; source_ref="R01UH0585EJ0120 section25.3; AppendixA TSG30/31"; behavior="tsg";
        writable_mask=0x3FE; reset_classes="power-on,system-1-cvm,system-1-pin,system-2,application-1";
        field { sw=w; reset=0x0; } value[15:0];
    } TSG30STC @ 0xFFE7001C;

    reg {
        regwidth=8; accesswidth=8; desc="TSG30OPT0";
        evidence="manual"; source_ref="R01UH0585EJ0120 section25.3; AppendixA TSG30/31"; behavior="tsg";
        writable_mask=0x7E; reset_classes="power-on,system-1-cvm,system-1-pin,system-2,application-1";
        field { sw=rw; reset=0x0; } value[7:0];
    } TSG30OPT0 @ 0xFFE70020;

    reg {
        regwidth=8; accesswidth=8; desc="TSG30OPT1";
        evidence="manual"; source_ref="R01UH0585EJ0120 section25.3; AppendixA TSG30/31"; behavior="tsg";
        writable_mask=0x7; reset_classes="power-on,system-1-cvm,system-1-pin,system-2,application-1";
        field { sw=rw; reset=0x0; } value[7:0];
    } TSG30OPT1 @ 0xFFE70024;

    reg {
        regwidth=16; accesswidth=16; desc="TSG30CNT";
        evidence="manual"; source_ref="R01UH0585EJ0120 section25.3; AppendixA TSG30/31"; behavior="tsg";
        writable_mask=0x0; reset_classes="power-on,system-1-cvm,system-1-pin,system-2,application-1";
        field { sw=r; reset=0x0; } value[15:0];
    } TSG30CNT @ 0xFFE70028;

    reg {
        regwidth=16; accesswidth=16; desc="TSG30SBC";
        evidence="manual"; source_ref="R01UH0585EJ0120 section25.3; AppendixA TSG30/31"; behavior="tsg";
        writable_mask=0x0; reset_classes="power-on,system-1-cvm,system-1-pin,system-2,application-1";
        field { sw=r; reset=0x0; } value[15:0];
    } TSG30SBC @ 0xFFE7002C;

    reg {
        regwidth=8; accesswidth=8; desc="TSG30TRG0";
        evidence="manual"; source_ref="R01UH0585EJ0120 section25.3; AppendixA TSG30/31"; behavior="tsg";
        writable_mask=0x1; reset_classes="power-on,system-1-cvm,system-1-pin,system-2,application-1";
        read_value=0;
        field { sw=w; reset=0x0; } value[7:0];
    } TSG30TRG0 @ 0xFFE70030;

    reg {
        regwidth=8; accesswidth=8; desc="TSG30TRG1";
        evidence="manual"; source_ref="R01UH0585EJ0120 section25.3; AppendixA TSG30/31"; behavior="tsg";
        writable_mask=0x1; reset_classes="power-on,system-1-cvm,system-1-pin,system-2,application-1";
        read_value=0;
        field { sw=w; reset=0x0; } value[7:0];
    } TSG30TRG1 @ 0xFFE70034;

    reg {
        regwidth=8; accesswidth=8; desc="TSG30TRG2";
        evidence="manual"; source_ref="R01UH0585EJ0120 section25.3; AppendixA TSG30/31"; behavior="tsg";
        writable_mask=0x1; reset_classes="power-on,system-1-cvm,system-1-pin,system-2,application-1";
        field { sw=w; reset=0x0; } value[7:0];
    } TSG30TRG2 @ 0xFFE70038;

    reg {
        regwidth=32; accesswidth=32; desc="TSG30DTC0W";
        evidence="manual"; source_ref="R01UH0585EJ0120 section25.3; AppendixA TSG30/31"; behavior="tsg";
        writable_mask=0x7FFF03FF; reset_classes="power-on,system-1-cvm,system-1-pin,system-2,application-1";
        field { sw=rw; reset=0x0; } value[31:0];
    } TSG30DTC0W @ 0xFFE7006C;

    reg {
        regwidth=32; accesswidth=32; desc="TSG30DTC1W";
        evidence="manual"; source_ref="R01UH0585EJ0120 section25.3; AppendixA TSG30/31"; behavior="tsg";
        writable_mask=0x7FFF03FF; reset_classes="power-on,system-1-cvm,system-1-pin,system-2,application-1";
        field { sw=rw; reset=0x0; } value[31:0];
    } TSG30DTC1W @ 0xFFE70070;

    reg {
        regwidth=32; accesswidth=32; desc="TSG30IOC3";
        evidence="manual"; source_ref="R01UH0585EJ0120 section25.3; AppendixA TSG30/31"; behavior="tsg";
        writable_mask=0x7E; reset_classes="power-on,system-1-cvm,system-1-pin,system-2,application-1";
        field { sw=rw; reset=0x0; } value[31:0];
    } TSG30IOC3 @ 0xFFE70074;

    reg {
        regwidth=32; accesswidth=32; desc="TSG30CTL2";
        evidence="manual"; source_ref="R01UH0585EJ0120 section25.3; AppendixA TSG30/31"; behavior="tsg";
        writable_mask=0x1; reset_classes="power-on,system-1-cvm,system-1-pin,system-2,application-1";
        field { sw=rw; reset=0x0; } value[31:0];
    } TSG30CTL2 @ 0xFFE70078;

    reg {
        regwidth=32; accesswidth=32; desc="TSG30CTL4";
        evidence="manual"; source_ref="R01UH0585EJ0120 section25.3; AppendixA TSG30/31"; behavior="tsg";
        writable_mask=0x1FF; reset_classes="power-on,system-1-cvm,system-1-pin,system-2,application-1";
        field { sw=rw; reset=0x0; } value[31:0];
    } TSG30CTL4 @ 0xFFE7007C;

    reg {
        regwidth=32; accesswidth=32; desc="TSG30DCMP2E";
        evidence="manual"; source_ref="R01UH0585EJ0120 section25.3; AppendixA TSG30/31"; behavior="tsg";
        writable_mask=0x3FFFF; reset_classes="power-on,system-1-cvm,system-1-pin,system-2,application-1";
        field { sw=rw; reset=0x0; } value[31:0];
    } TSG30DCMP2E @ 0xFFE70140;

    reg {
        regwidth=32; accesswidth=32; desc="TSG30DCMP1E";
        evidence="manual"; source_ref="R01UH0585EJ0120 section25.3; AppendixA TSG30/31"; behavior="tsg";
        writable_mask=0x3FFFF; reset_classes="power-on,system-1-cvm,system-1-pin,system-2,application-1";
        field { sw=rw; reset=0x0; } value[31:0];
    } TSG30DCMP1E @ 0xFFE70144;

    reg {
        regwidth=32; accesswidth=32; desc="TSG30DCMP0E";
        evidence="manual"; source_ref="R01UH0585EJ0120 section25.3; AppendixA TSG30/31"; behavior="tsg";
        writable_mask=0x3FFFF; reset_classes="power-on,system-1-cvm,system-1-pin,system-2,application-1";
        field { sw=rw; reset=0x0; } value[31:0];
    } TSG30DCMP0E @ 0xFFE70148;

    reg {
        regwidth=32; accesswidth=32; desc="TSG30CMP0E";
        evidence="manual"; source_ref="R01UH0585EJ0120 section25.3; AppendixA TSG30/31"; behavior="tsg";
        writable_mask=0x3FFFF; reset_classes="power-on,system-1-cvm,system-1-pin,system-2,application-1";
        field { sw=rw; reset=0x0; } value[31:0];
    } TSG30CMP0E @ 0xFFE7014C;

    reg {
        regwidth=32; accesswidth=32; desc="TSG30CMP12E";
        evidence="manual"; source_ref="R01UH0585EJ0120 section25.3; AppendixA TSG30/31"; behavior="tsg";
        writable_mask=0x3FFFF; reset_classes="power-on,system-1-cvm,system-1-pin,system-2,application-1";
        field { sw=rw; reset=0x0; } value[31:0];
    } TSG30CMP12E @ 0xFFE70150;

    reg {
        regwidth=32; accesswidth=32; desc="TSG30CMP11E";
        evidence="manual"; source_ref="R01UH0585EJ0120 section25.3; AppendixA TSG30/31"; behavior="tsg";
        writable_mask=0x3FFFF; reset_classes="power-on,system-1-cvm,system-1-pin,system-2,application-1";
        field { sw=rw; reset=0x0; } value[31:0];
    } TSG30CMP11E @ 0xFFE70154;

    reg {
        regwidth=32; accesswidth=32; desc="TSG30CMP8E";
        evidence="manual"; source_ref="R01UH0585EJ0120 section25.3; AppendixA TSG30/31"; behavior="tsg";
        writable_mask=0x3FFFF; reset_classes="power-on,system-1-cvm,system-1-pin,system-2,application-1";
        field { sw=rw; reset=0x0; } value[31:0];
    } TSG30CMP8E @ 0xFFE70158;

    reg {
        regwidth=32; accesswidth=32; desc="TSG30CMP7E";
        evidence="manual"; source_ref="R01UH0585EJ0120 section25.3; AppendixA TSG30/31"; behavior="tsg";
        writable_mask=0x3FFFF; reset_classes="power-on,system-1-cvm,system-1-pin,system-2,application-1";
        field { sw=rw; reset=0x0; } value[31:0];
    } TSG30CMP7E @ 0xFFE7015C;

    reg {
        regwidth=32; accesswidth=32; desc="TSG30CMP4E";
        evidence="manual"; source_ref="R01UH0585EJ0120 section25.3; AppendixA TSG30/31"; behavior="tsg";
        writable_mask=0x3FFFF; reset_classes="power-on,system-1-cvm,system-1-pin,system-2,application-1";
        field { sw=rw; reset=0x0; } value[31:0];
    } TSG30CMP4E @ 0xFFE70160;

    reg {
        regwidth=32; accesswidth=32; desc="TSG30CMP3E";
        evidence="manual"; source_ref="R01UH0585EJ0120 section25.3; AppendixA TSG30/31"; behavior="tsg";
        writable_mask=0x3FFFF; reset_classes="power-on,system-1-cvm,system-1-pin,system-2,application-1";
        field { sw=rw; reset=0x0; } value[31:0];
    } TSG30CMP3E @ 0xFFE70164;

    reg {
        regwidth=32; accesswidth=32; desc="TSG30CMP10E";
        evidence="manual"; source_ref="R01UH0585EJ0120 section25.3; AppendixA TSG30/31"; behavior="tsg";
        writable_mask=0x3FFFF; reset_classes="power-on,system-1-cvm,system-1-pin,system-2,application-1";
        field { sw=rw; reset=0x0; } value[31:0];
    } TSG30CMP10E @ 0xFFE70168;

    reg {
        regwidth=32; accesswidth=32; desc="TSG30CMP9E";
        evidence="manual"; source_ref="R01UH0585EJ0120 section25.3; AppendixA TSG30/31"; behavior="tsg";
        writable_mask=0x3FFFF; reset_classes="power-on,system-1-cvm,system-1-pin,system-2,application-1";
        field { sw=rw; reset=0x0; } value[31:0];
    } TSG30CMP9E @ 0xFFE7016C;

    reg {
        regwidth=32; accesswidth=32; desc="TSG30CMP6E";
        evidence="manual"; source_ref="R01UH0585EJ0120 section25.3; AppendixA TSG30/31"; behavior="tsg";
        writable_mask=0x3FFFF; reset_classes="power-on,system-1-cvm,system-1-pin,system-2,application-1";
        field { sw=rw; reset=0x0; } value[31:0];
    } TSG30CMP6E @ 0xFFE70170;

    reg {
        regwidth=32; accesswidth=32; desc="TSG30CMP5E";
        evidence="manual"; source_ref="R01UH0585EJ0120 section25.3; AppendixA TSG30/31"; behavior="tsg";
        writable_mask=0x3FFFF; reset_classes="power-on,system-1-cvm,system-1-pin,system-2,application-1";
        field { sw=rw; reset=0x0; } value[31:0];
    } TSG30CMP5E @ 0xFFE70174;

    reg {
        regwidth=32; accesswidth=32; desc="TSG30CMP2E";
        evidence="manual"; source_ref="R01UH0585EJ0120 section25.3; AppendixA TSG30/31"; behavior="tsg";
        writable_mask=0x3FFFF; reset_classes="power-on,system-1-cvm,system-1-pin,system-2,application-1";
        field { sw=rw; reset=0x0; } value[31:0];
    } TSG30CMP2E @ 0xFFE70178;

    reg {
        regwidth=32; accesswidth=32; desc="TSG30CMP1E";
        evidence="manual"; source_ref="R01UH0585EJ0120 section25.3; AppendixA TSG30/31"; behavior="tsg";
        writable_mask=0x3FFFF; reset_classes="power-on,system-1-cvm,system-1-pin,system-2,application-1";
        field { sw=rw; reset=0x0; } value[31:0];
    } TSG30CMP1E @ 0xFFE7017C;

    reg {
        regwidth=32; accesswidth=32; desc="TSG30CMPWE";
        evidence="manual"; source_ref="R01UH0585EJ0120 section25.3; AppendixA TSG30/31"; behavior="tsg";
        writable_mask=0x3FFFF; reset_classes="power-on,system-1-cvm,system-1-pin,system-2,application-1";
        field { sw=rw; reset=0x0; } value[31:0];
    } TSG30CMPWE @ 0xFFE70180;

    reg {
        regwidth=32; accesswidth=32; desc="TSG30CMPVE";
        evidence="manual"; source_ref="R01UH0585EJ0120 section25.3; AppendixA TSG30/31"; behavior="tsg";
        writable_mask=0x3FFFF; reset_classes="power-on,system-1-cvm,system-1-pin,system-2,application-1";
        field { sw=rw; reset=0x0; } value[31:0];
    } TSG30CMPVE @ 0xFFE70184;

    reg {
        regwidth=32; accesswidth=32; desc="TSG30CMPUE";
        evidence="manual"; source_ref="R01UH0585EJ0120 section25.3; AppendixA TSG30/31"; behavior="tsg";
        writable_mask=0x3FFFF; reset_classes="power-on,system-1-cvm,system-1-pin,system-2,application-1";
        field { sw=rw; reset=0x0; } value[31:0];
    } TSG30CMPUE @ 0xFFE70188;

    reg {
        regwidth=32; accesswidth=32; desc="TSG30CNTE";
        evidence="manual"; source_ref="R01UH0585EJ0120 section25.3; AppendixA TSG30/31"; behavior="tsg";
        writable_mask=0x0; reset_classes="power-on,system-1-cvm,system-1-pin,system-2,application-1";
        field { sw=r; reset=0x0; } value[31:0];
    } TSG30CNTE @ 0xFFE701A0;

    reg {
        regwidth=32; accesswidth=32; desc="TSG30SBCE";
        evidence="manual"; source_ref="R01UH0585EJ0120 section25.3; AppendixA TSG30/31"; behavior="tsg";
        writable_mask=0x0; reset_classes="power-on,system-1-cvm,system-1-pin,system-2,application-1";
        field { sw=r; reset=0x0; } value[31:0];
    } TSG30SBCE @ 0xFFE701A4;

    reg {
        regwidth=8; accesswidth=8; desc="TSG30IOC0";
        evidence="manual"; source_ref="R01UH0585EJ0120 section25.3; AppendixA TSG30/31"; behavior="tsg";
        writable_mask=0x7E; reset_classes="power-on,system-1-cvm,system-1-pin,system-2,application-1";
        field { sw=rw; reset=0x7E; } value[7:0];
    } TSG30IOC0 @ 0xFFE70200;

    reg {
        regwidth=8; accesswidth=8; desc="TSG30IOC1";
        evidence="manual"; source_ref="R01UH0585EJ0120 section25.3; AppendixA TSG30/31"; behavior="tsg";
        writable_mask=0x1F; reset_classes="power-on,system-1-cvm,system-1-pin,system-2,application-1";
        field { sw=rw; reset=0x0; } value[7:0];
    } TSG30IOC1 @ 0xFFE70204;

    reg {
        regwidth=8; accesswidth=8; desc="TSG30CTL0";
        evidence="manual"; source_ref="R01UH0585EJ0120 section25.3; AppendixA TSG30/31"; behavior="tsg";
        writable_mask=0x17; reset_classes="power-on,system-1-cvm,system-1-pin,system-2,application-1";
        field { sw=rw; reset=0x0; } value[7:0];
    } TSG30CTL0 @ 0xFFE70208;

    reg {
        regwidth=16; accesswidth=16; desc="TSG30CTL1";
        evidence="manual"; source_ref="R01UH0585EJ0120 section25.3; AppendixA TSG30/31"; behavior="tsg";
        writable_mask=0x3FF; reset_classes="power-on,system-1-cvm,system-1-pin,system-2,application-1";
        field { sw=rw; reset=0x0; } value[15:0];
    } TSG30CTL1 @ 0xFFE7020C;

    reg {
        regwidth=16; accesswidth=16; desc="TSG30DTPR";
        evidence="manual"; source_ref="R01UH0585EJ0120 section25.3; AppendixA TSG30/31"; behavior="tsg";
        writable_mask=0xFFFF; reset_classes="power-on,system-1-cvm,system-1-pin,system-2,application-1";
        field { sw=rw; reset=0x0; } value[15:0];
    } TSG30DTPR @ 0xFFE70210;

    reg {
        regwidth=16; accesswidth=16; desc="TSG31IOC2";
        evidence="manual"; source_ref="R01UH0585EJ0120 section25.3; AppendixA TSG30/31"; behavior="tsg";
        writable_mask=0x7E7E; reset_classes="power-on,system-1-cvm,system-1-pin,system-2,application-1";
        field { sw=rw; reset=0x0; } value[15:0];
    } TSG31IOC2 @ 0xFFE71000;

    reg {
        regwidth=8; accesswidth=8; desc="TSG31CTL3";
        evidence="manual"; source_ref="R01UH0585EJ0120 section25.3; AppendixA TSG30/31"; behavior="tsg";
        writable_mask=0x3; reset_classes="power-on,system-1-cvm,system-1-pin,system-2,application-1";
        field { sw=rw; reset=0x0; } value[7:0];
    } TSG31CTL3 @ 0xFFE71004;

    reg {
        regwidth=16; accesswidth=16; desc="TSG31CTL5";
        evidence="manual"; source_ref="R01UH0585EJ0120 section25.3; AppendixA TSG30/31"; behavior="tsg";
        writable_mask=0xFFF; reset_classes="power-on,system-1-cvm,system-1-pin,system-2,application-1";
        field { sw=rw; reset=0x0; } value[15:0];
    } TSG31CTL5 @ 0xFFE71008;

    reg {
        regwidth=16; accesswidth=16; desc="TSG31CTL6";
        evidence="manual"; source_ref="R01UH0585EJ0120 section25.3; AppendixA TSG30/31"; behavior="tsg";
        writable_mask=0xFFF; reset_classes="power-on,system-1-cvm,system-1-pin,system-2,application-1";
        field { sw=rw; reset=0x0; } value[15:0];
    } TSG31CTL6 @ 0xFFE7100C;

    reg {
        regwidth=8; accesswidth=8; desc="TSG31STR0";
        evidence="manual"; source_ref="R01UH0585EJ0120 section25.3; AppendixA TSG30/31"; behavior="tsg";
        writable_mask=0x0; reset_classes="power-on,system-1-cvm,system-1-pin,system-2,application-1";
        field { sw=r; reset=0x0; } value[7:0];
    } TSG31STR0 @ 0xFFE71010;

    reg {
        regwidth=8; accesswidth=8; desc="TSG31STR1";
        evidence="manual"; source_ref="R01UH0585EJ0120 section25.3; AppendixA TSG30/31"; behavior="tsg";
        writable_mask=0x0; reset_classes="power-on,system-1-cvm,system-1-pin,system-2,application-1";
        field { sw=r; reset=0x0; } value[7:0];
    } TSG31STR1 @ 0xFFE71014;

    reg {
        regwidth=16; accesswidth=16; desc="TSG31STR2";
        evidence="manual"; source_ref="R01UH0585EJ0120 section25.3; AppendixA TSG30/31"; behavior="tsg";
        writable_mask=0x0; reset_classes="power-on,system-1-cvm,system-1-pin,system-2,application-1";
        field { sw=r; reset=0x0; } value[15:0];
    } TSG31STR2 @ 0xFFE71018;

    reg {
        regwidth=16; accesswidth=16; desc="TSG31STC";
        evidence="manual"; source_ref="R01UH0585EJ0120 section25.3; AppendixA TSG30/31"; behavior="tsg";
        writable_mask=0x3FE; reset_classes="power-on,system-1-cvm,system-1-pin,system-2,application-1";
        field { sw=w; reset=0x0; } value[15:0];
    } TSG31STC @ 0xFFE7101C;

    reg {
        regwidth=8; accesswidth=8; desc="TSG31OPT0";
        evidence="manual"; source_ref="R01UH0585EJ0120 section25.3; AppendixA TSG30/31"; behavior="tsg";
        writable_mask=0x7E; reset_classes="power-on,system-1-cvm,system-1-pin,system-2,application-1";
        field { sw=rw; reset=0x0; } value[7:0];
    } TSG31OPT0 @ 0xFFE71020;

    reg {
        regwidth=8; accesswidth=8; desc="TSG31OPT1";
        evidence="manual"; source_ref="R01UH0585EJ0120 section25.3; AppendixA TSG30/31"; behavior="tsg";
        writable_mask=0x7; reset_classes="power-on,system-1-cvm,system-1-pin,system-2,application-1";
        field { sw=rw; reset=0x0; } value[7:0];
    } TSG31OPT1 @ 0xFFE71024;

    reg {
        regwidth=16; accesswidth=16; desc="TSG31CNT";
        evidence="manual"; source_ref="R01UH0585EJ0120 section25.3; AppendixA TSG30/31"; behavior="tsg";
        writable_mask=0x0; reset_classes="power-on,system-1-cvm,system-1-pin,system-2,application-1";
        field { sw=r; reset=0x0; } value[15:0];
    } TSG31CNT @ 0xFFE71028;

    reg {
        regwidth=16; accesswidth=16; desc="TSG31SBC";
        evidence="manual"; source_ref="R01UH0585EJ0120 section25.3; AppendixA TSG30/31"; behavior="tsg";
        writable_mask=0x0; reset_classes="power-on,system-1-cvm,system-1-pin,system-2,application-1";
        field { sw=r; reset=0x0; } value[15:0];
    } TSG31SBC @ 0xFFE7102C;

    reg {
        regwidth=8; accesswidth=8; desc="TSG31TRG0";
        evidence="manual"; source_ref="R01UH0585EJ0120 section25.3; AppendixA TSG30/31"; behavior="tsg";
        writable_mask=0x1; reset_classes="power-on,system-1-cvm,system-1-pin,system-2,application-1";
        read_value=0;
        field { sw=w; reset=0x0; } value[7:0];
    } TSG31TRG0 @ 0xFFE71030;

    reg {
        regwidth=8; accesswidth=8; desc="TSG31TRG1";
        evidence="manual"; source_ref="R01UH0585EJ0120 section25.3; AppendixA TSG30/31"; behavior="tsg";
        writable_mask=0x1; reset_classes="power-on,system-1-cvm,system-1-pin,system-2,application-1";
        read_value=0;
        field { sw=w; reset=0x0; } value[7:0];
    } TSG31TRG1 @ 0xFFE71034;

    reg {
        regwidth=8; accesswidth=8; desc="TSG31TRG2";
        evidence="manual"; source_ref="R01UH0585EJ0120 section25.3; AppendixA TSG30/31"; behavior="tsg";
        writable_mask=0x1; reset_classes="power-on,system-1-cvm,system-1-pin,system-2,application-1";
        field { sw=w; reset=0x0; } value[7:0];
    } TSG31TRG2 @ 0xFFE71038;

    reg {
        regwidth=32; accesswidth=32; desc="TSG31DTC0W";
        evidence="manual"; source_ref="R01UH0585EJ0120 section25.3; AppendixA TSG30/31"; behavior="tsg";
        writable_mask=0x7FFF03FF; reset_classes="power-on,system-1-cvm,system-1-pin,system-2,application-1";
        field { sw=rw; reset=0x0; } value[31:0];
    } TSG31DTC0W @ 0xFFE7106C;

    reg {
        regwidth=32; accesswidth=32; desc="TSG31DTC1W";
        evidence="manual"; source_ref="R01UH0585EJ0120 section25.3; AppendixA TSG30/31"; behavior="tsg";
        writable_mask=0x7FFF03FF; reset_classes="power-on,system-1-cvm,system-1-pin,system-2,application-1";
        field { sw=rw; reset=0x0; } value[31:0];
    } TSG31DTC1W @ 0xFFE71070;

    reg {
        regwidth=32; accesswidth=32; desc="TSG31IOC3";
        evidence="manual"; source_ref="R01UH0585EJ0120 section25.3; AppendixA TSG30/31"; behavior="tsg";
        writable_mask=0x7E; reset_classes="power-on,system-1-cvm,system-1-pin,system-2,application-1";
        field { sw=rw; reset=0x0; } value[31:0];
    } TSG31IOC3 @ 0xFFE71074;

    reg {
        regwidth=32; accesswidth=32; desc="TSG31CTL2";
        evidence="manual"; source_ref="R01UH0585EJ0120 section25.3; AppendixA TSG30/31"; behavior="tsg";
        writable_mask=0x1; reset_classes="power-on,system-1-cvm,system-1-pin,system-2,application-1";
        field { sw=rw; reset=0x0; } value[31:0];
    } TSG31CTL2 @ 0xFFE71078;

    reg {
        regwidth=32; accesswidth=32; desc="TSG31CTL4";
        evidence="manual"; source_ref="R01UH0585EJ0120 section25.3; AppendixA TSG30/31"; behavior="tsg";
        writable_mask=0x1FF; reset_classes="power-on,system-1-cvm,system-1-pin,system-2,application-1";
        field { sw=rw; reset=0x0; } value[31:0];
    } TSG31CTL4 @ 0xFFE7107C;

    reg {
        regwidth=32; accesswidth=32; desc="TSG31DCMP2E";
        evidence="manual"; source_ref="R01UH0585EJ0120 section25.3; AppendixA TSG30/31"; behavior="tsg";
        writable_mask=0x3FFFF; reset_classes="power-on,system-1-cvm,system-1-pin,system-2,application-1";
        field { sw=rw; reset=0x0; } value[31:0];
    } TSG31DCMP2E @ 0xFFE71140;

    reg {
        regwidth=32; accesswidth=32; desc="TSG31DCMP1E";
        evidence="manual"; source_ref="R01UH0585EJ0120 section25.3; AppendixA TSG30/31"; behavior="tsg";
        writable_mask=0x3FFFF; reset_classes="power-on,system-1-cvm,system-1-pin,system-2,application-1";
        field { sw=rw; reset=0x0; } value[31:0];
    } TSG31DCMP1E @ 0xFFE71144;

    reg {
        regwidth=32; accesswidth=32; desc="TSG31DCMP0E";
        evidence="manual"; source_ref="R01UH0585EJ0120 section25.3; AppendixA TSG30/31"; behavior="tsg";
        writable_mask=0x3FFFF; reset_classes="power-on,system-1-cvm,system-1-pin,system-2,application-1";
        field { sw=rw; reset=0x0; } value[31:0];
    } TSG31DCMP0E @ 0xFFE71148;

    reg {
        regwidth=32; accesswidth=32; desc="TSG31CMP0E";
        evidence="manual"; source_ref="R01UH0585EJ0120 section25.3; AppendixA TSG30/31"; behavior="tsg";
        writable_mask=0x3FFFF; reset_classes="power-on,system-1-cvm,system-1-pin,system-2,application-1";
        field { sw=rw; reset=0x0; } value[31:0];
    } TSG31CMP0E @ 0xFFE7114C;

    reg {
        regwidth=32; accesswidth=32; desc="TSG31CMP12E";
        evidence="manual"; source_ref="R01UH0585EJ0120 section25.3; AppendixA TSG30/31"; behavior="tsg";
        writable_mask=0x3FFFF; reset_classes="power-on,system-1-cvm,system-1-pin,system-2,application-1";
        field { sw=rw; reset=0x0; } value[31:0];
    } TSG31CMP12E @ 0xFFE71150;

    reg {
        regwidth=32; accesswidth=32; desc="TSG31CMP11E";
        evidence="manual"; source_ref="R01UH0585EJ0120 section25.3; AppendixA TSG30/31"; behavior="tsg";
        writable_mask=0x3FFFF; reset_classes="power-on,system-1-cvm,system-1-pin,system-2,application-1";
        field { sw=rw; reset=0x0; } value[31:0];
    } TSG31CMP11E @ 0xFFE71154;

    reg {
        regwidth=32; accesswidth=32; desc="TSG31CMP8E";
        evidence="manual"; source_ref="R01UH0585EJ0120 section25.3; AppendixA TSG30/31"; behavior="tsg";
        writable_mask=0x3FFFF; reset_classes="power-on,system-1-cvm,system-1-pin,system-2,application-1";
        field { sw=rw; reset=0x0; } value[31:0];
    } TSG31CMP8E @ 0xFFE71158;

    reg {
        regwidth=32; accesswidth=32; desc="TSG31CMP7E";
        evidence="manual"; source_ref="R01UH0585EJ0120 section25.3; AppendixA TSG30/31"; behavior="tsg";
        writable_mask=0x3FFFF; reset_classes="power-on,system-1-cvm,system-1-pin,system-2,application-1";
        field { sw=rw; reset=0x0; } value[31:0];
    } TSG31CMP7E @ 0xFFE7115C;

    reg {
        regwidth=32; accesswidth=32; desc="TSG31CMP4E";
        evidence="manual"; source_ref="R01UH0585EJ0120 section25.3; AppendixA TSG30/31"; behavior="tsg";
        writable_mask=0x3FFFF; reset_classes="power-on,system-1-cvm,system-1-pin,system-2,application-1";
        field { sw=rw; reset=0x0; } value[31:0];
    } TSG31CMP4E @ 0xFFE71160;

    reg {
        regwidth=32; accesswidth=32; desc="TSG31CMP3E";
        evidence="manual"; source_ref="R01UH0585EJ0120 section25.3; AppendixA TSG30/31"; behavior="tsg";
        writable_mask=0x3FFFF; reset_classes="power-on,system-1-cvm,system-1-pin,system-2,application-1";
        field { sw=rw; reset=0x0; } value[31:0];
    } TSG31CMP3E @ 0xFFE71164;

    reg {
        regwidth=32; accesswidth=32; desc="TSG31CMP10E";
        evidence="manual"; source_ref="R01UH0585EJ0120 section25.3; AppendixA TSG30/31"; behavior="tsg";
        writable_mask=0x3FFFF; reset_classes="power-on,system-1-cvm,system-1-pin,system-2,application-1";
        field { sw=rw; reset=0x0; } value[31:0];
    } TSG31CMP10E @ 0xFFE71168;

    reg {
        regwidth=32; accesswidth=32; desc="TSG31CMP9E";
        evidence="manual"; source_ref="R01UH0585EJ0120 section25.3; AppendixA TSG30/31"; behavior="tsg";
        writable_mask=0x3FFFF; reset_classes="power-on,system-1-cvm,system-1-pin,system-2,application-1";
        field { sw=rw; reset=0x0; } value[31:0];
    } TSG31CMP9E @ 0xFFE7116C;

    reg {
        regwidth=32; accesswidth=32; desc="TSG31CMP6E";
        evidence="manual"; source_ref="R01UH0585EJ0120 section25.3; AppendixA TSG30/31"; behavior="tsg";
        writable_mask=0x3FFFF; reset_classes="power-on,system-1-cvm,system-1-pin,system-2,application-1";
        field { sw=rw; reset=0x0; } value[31:0];
    } TSG31CMP6E @ 0xFFE71170;

    reg {
        regwidth=32; accesswidth=32; desc="TSG31CMP5E";
        evidence="manual"; source_ref="R01UH0585EJ0120 section25.3; AppendixA TSG30/31"; behavior="tsg";
        writable_mask=0x3FFFF; reset_classes="power-on,system-1-cvm,system-1-pin,system-2,application-1";
        field { sw=rw; reset=0x0; } value[31:0];
    } TSG31CMP5E @ 0xFFE71174;

    reg {
        regwidth=32; accesswidth=32; desc="TSG31CMP2E";
        evidence="manual"; source_ref="R01UH0585EJ0120 section25.3; AppendixA TSG30/31"; behavior="tsg";
        writable_mask=0x3FFFF; reset_classes="power-on,system-1-cvm,system-1-pin,system-2,application-1";
        field { sw=rw; reset=0x0; } value[31:0];
    } TSG31CMP2E @ 0xFFE71178;

    reg {
        regwidth=32; accesswidth=32; desc="TSG31CMP1E";
        evidence="manual"; source_ref="R01UH0585EJ0120 section25.3; AppendixA TSG30/31"; behavior="tsg";
        writable_mask=0x3FFFF; reset_classes="power-on,system-1-cvm,system-1-pin,system-2,application-1";
        field { sw=rw; reset=0x0; } value[31:0];
    } TSG31CMP1E @ 0xFFE7117C;

    reg {
        regwidth=32; accesswidth=32; desc="TSG31CMPWE";
        evidence="manual"; source_ref="R01UH0585EJ0120 section25.3; AppendixA TSG30/31"; behavior="tsg";
        writable_mask=0x3FFFF; reset_classes="power-on,system-1-cvm,system-1-pin,system-2,application-1";
        field { sw=rw; reset=0x0; } value[31:0];
    } TSG31CMPWE @ 0xFFE71180;

    reg {
        regwidth=32; accesswidth=32; desc="TSG31CMPVE";
        evidence="manual"; source_ref="R01UH0585EJ0120 section25.3; AppendixA TSG30/31"; behavior="tsg";
        writable_mask=0x3FFFF; reset_classes="power-on,system-1-cvm,system-1-pin,system-2,application-1";
        field { sw=rw; reset=0x0; } value[31:0];
    } TSG31CMPVE @ 0xFFE71184;

    reg {
        regwidth=32; accesswidth=32; desc="TSG31CMPUE";
        evidence="manual"; source_ref="R01UH0585EJ0120 section25.3; AppendixA TSG30/31"; behavior="tsg";
        writable_mask=0x3FFFF; reset_classes="power-on,system-1-cvm,system-1-pin,system-2,application-1";
        field { sw=rw; reset=0x0; } value[31:0];
    } TSG31CMPUE @ 0xFFE71188;

    reg {
        regwidth=32; accesswidth=32; desc="TSG31CNTE";
        evidence="manual"; source_ref="R01UH0585EJ0120 section25.3; AppendixA TSG30/31"; behavior="tsg";
        writable_mask=0x0; reset_classes="power-on,system-1-cvm,system-1-pin,system-2,application-1";
        field { sw=r; reset=0x0; } value[31:0];
    } TSG31CNTE @ 0xFFE711A0;

    reg {
        regwidth=32; accesswidth=32; desc="TSG31SBCE";
        evidence="manual"; source_ref="R01UH0585EJ0120 section25.3; AppendixA TSG30/31"; behavior="tsg";
        writable_mask=0x0; reset_classes="power-on,system-1-cvm,system-1-pin,system-2,application-1";
        field { sw=r; reset=0x0; } value[31:0];
    } TSG31SBCE @ 0xFFE711A4;

    reg {
        regwidth=8; accesswidth=8; desc="TSG31IOC0";
        evidence="manual"; source_ref="R01UH0585EJ0120 section25.3; AppendixA TSG30/31"; behavior="tsg";
        writable_mask=0x7E; reset_classes="power-on,system-1-cvm,system-1-pin,system-2,application-1";
        field { sw=rw; reset=0x7E; } value[7:0];
    } TSG31IOC0 @ 0xFFE71200;

    reg {
        regwidth=8; accesswidth=8; desc="TSG31IOC1";
        evidence="manual"; source_ref="R01UH0585EJ0120 section25.3; AppendixA TSG30/31"; behavior="tsg";
        writable_mask=0x1F; reset_classes="power-on,system-1-cvm,system-1-pin,system-2,application-1";
        field { sw=rw; reset=0x0; } value[7:0];
    } TSG31IOC1 @ 0xFFE71204;

    reg {
        regwidth=8; accesswidth=8; desc="TSG31CTL0";
        evidence="manual"; source_ref="R01UH0585EJ0120 section25.3; AppendixA TSG30/31"; behavior="tsg";
        writable_mask=0x17; reset_classes="power-on,system-1-cvm,system-1-pin,system-2,application-1";
        field { sw=rw; reset=0x0; } value[7:0];
    } TSG31CTL0 @ 0xFFE71208;

    reg {
        regwidth=16; accesswidth=16; desc="TSG31CTL1";
        evidence="manual"; source_ref="R01UH0585EJ0120 section25.3; AppendixA TSG30/31"; behavior="tsg";
        writable_mask=0x3FF; reset_classes="power-on,system-1-cvm,system-1-pin,system-2,application-1";
        field { sw=rw; reset=0x0; } value[15:0];
    } TSG31CTL1 @ 0xFFE7120C;

    reg {
        regwidth=16; accesswidth=16; desc="TSG31DTPR";
        evidence="manual"; source_ref="R01UH0585EJ0120 section25.3; AppendixA TSG30/31"; behavior="tsg";
        writable_mask=0xFFFF; reset_classes="power-on,system-1-cvm,system-1-pin,system-2,application-1";
        field { sw=rw; reset=0x0; } value[15:0];
    } TSG31DTPR @ 0xFFE71210;

    reg {
        regwidth=32; accesswidth=32; desc="PIC2BADCG0TSEL0";
        evidence="manual"; source_ref="R01UH0585EJ0120 Table29.43; TSG source OR before scan-group edge selection"; behavior="pic-tsg";
        writable_mask=0x3F3F01FF; reset_classes="power-on,system-1-cvm,system-1-pin,system-2,application-1";
        field { sw=rw; reset=0x0; } value[31:0];
    } PIC2BADCG0TSEL0 @ 0xFFDD1000;

    reg {
        regwidth=32; accesswidth=32; desc="PIC2BADCG0TSEL1";
        evidence="manual"; source_ref="R01UH0585EJ0120 Table29.43; TSG source OR before scan-group edge selection"; behavior="pic-tsg";
        writable_mask=0x3F3F01FF; reset_classes="power-on,system-1-cvm,system-1-pin,system-2,application-1";
        field { sw=rw; reset=0x0; } value[31:0];
    } PIC2BADCG0TSEL1 @ 0xFFDD1004;

    reg {
        regwidth=32; accesswidth=32; desc="PIC2BADCG0TSEL2";
        evidence="manual"; source_ref="R01UH0585EJ0120 Table29.43; TSG source OR before scan-group edge selection"; behavior="pic-tsg";
        writable_mask=0x3F3F01FF; reset_classes="power-on,system-1-cvm,system-1-pin,system-2,application-1";
        field { sw=rw; reset=0x0; } value[31:0];
    } PIC2BADCG0TSEL2 @ 0xFFDD1008;

    reg {
        regwidth=32; accesswidth=32; desc="PIC2BADCG0TSEL3";
        evidence="manual"; source_ref="R01UH0585EJ0120 Table29.43; TSG source OR before scan-group edge selection"; behavior="pic-tsg";
        writable_mask=0x3F3F01FF; reset_classes="power-on,system-1-cvm,system-1-pin,system-2,application-1";
        field { sw=rw; reset=0x0; } value[31:0];
    } PIC2BADCG0TSEL3 @ 0xFFDD100C;

    reg {
        regwidth=32; accesswidth=32; desc="PIC2BADCG0TSEL4";
        evidence="manual"; source_ref="R01UH0585EJ0120 Table29.43; TSG source OR before scan-group edge selection"; behavior="pic-tsg";
        writable_mask=0x3F3F01FF; reset_classes="power-on,system-1-cvm,system-1-pin,system-2,application-1";
        field { sw=rw; reset=0x0; } value[31:0];
    } PIC2BADCG0TSEL4 @ 0xFFDD1010;

    reg {
        regwidth=16; accesswidth=16; desc="PIC2BADCG0EDGSEL";
        evidence="manual"; source_ref="R01UH0585EJ0120 Table29.44; rising0 falling1 both2 prohibited3"; behavior="pic-tsg";
        writable_mask=0x3FF; reset_classes="power-on,system-1-cvm,system-1-pin,system-2,application-1";
        field { sw=rw; reset=0x0; } value[15:0];
    } PIC2BADCG0EDGSEL @ 0xFFDD101C;

    reg {
        regwidth=32; accesswidth=32; desc="PIC2BADCG1TSEL0";
        evidence="manual"; source_ref="R01UH0585EJ0120 Table29.43; TSG source OR before scan-group edge selection"; behavior="pic-tsg";
        writable_mask=0x3F3F01FF; reset_classes="power-on,system-1-cvm,system-1-pin,system-2,application-1";
        field { sw=rw; reset=0x0; } value[31:0];
    } PIC2BADCG1TSEL0 @ 0xFFDD1020;

    reg {
        regwidth=32; accesswidth=32; desc="PIC2BADCG1TSEL1";
        evidence="manual"; source_ref="R01UH0585EJ0120 Table29.43; TSG source OR before scan-group edge selection"; behavior="pic-tsg";
        writable_mask=0x3F3F01FF; reset_classes="power-on,system-1-cvm,system-1-pin,system-2,application-1";
        field { sw=rw; reset=0x0; } value[31:0];
    } PIC2BADCG1TSEL1 @ 0xFFDD1024;

    reg {
        regwidth=32; accesswidth=32; desc="PIC2BADCG1TSEL2";
        evidence="manual"; source_ref="R01UH0585EJ0120 Table29.43; TSG source OR before scan-group edge selection"; behavior="pic-tsg";
        writable_mask=0x3F3F01FF; reset_classes="power-on,system-1-cvm,system-1-pin,system-2,application-1";
        field { sw=rw; reset=0x0; } value[31:0];
    } PIC2BADCG1TSEL2 @ 0xFFDD1028;

    reg {
        regwidth=32; accesswidth=32; desc="PIC2BADCG1TSEL3";
        evidence="manual"; source_ref="R01UH0585EJ0120 Table29.43; TSG source OR before scan-group edge selection"; behavior="pic-tsg";
        writable_mask=0x3F3F01FF; reset_classes="power-on,system-1-cvm,system-1-pin,system-2,application-1";
        field { sw=rw; reset=0x0; } value[31:0];
    } PIC2BADCG1TSEL3 @ 0xFFDD102C;

    reg {
        regwidth=32; accesswidth=32; desc="PIC2BADCG1TSEL4";
        evidence="manual"; source_ref="R01UH0585EJ0120 Table29.43; TSG source OR before scan-group edge selection"; behavior="pic-tsg";
        writable_mask=0x3F3F01FF; reset_classes="power-on,system-1-cvm,system-1-pin,system-2,application-1";
        field { sw=rw; reset=0x0; } value[31:0];
    } PIC2BADCG1TSEL4 @ 0xFFDD1030;

    reg {
        regwidth=16; accesswidth=16; desc="PIC2BADCG1EDGSEL";
        evidence="manual"; source_ref="R01UH0585EJ0120 Table29.44; rising0 falling1 both2 prohibited3"; behavior="pic-tsg";
        writable_mask=0x3FF; reset_classes="power-on,system-1-cvm,system-1-pin,system-2,application-1";
        field { sw=rw; reset=0x0; } value[15:0];
    } PIC2BADCG1EDGSEL @ 0xFFDD103C;

    reg {
        regwidth=32; accesswidth=32; desc="RAM initialization mode control for Global RAM; reset value 0x00000003";
        evidence="manual"; source_ref="R01UH0585EJ0120 sections 8.3.7-8.3.8"; behavior="reset_stac";
        field { sw=rw; reset=3; } value[31:0];
    } STAC_GRAM @ 0xFFF81420;

    reg {
        regwidth=32; accesswidth=32; desc="RAM initialization mode control for Local RAM; reset value 0x00000003";
        evidence="manual"; source_ref="R01UH0585EJ0120 sections 8.3.7-8.3.8"; behavior="reset_stac";
        field { sw=rw; reset=3; } value[31:0];
    } STAC_LM0 @ 0xFFF81520;

    reg {
        regwidth=32; accesswidth=32; desc="EXTCLK1O divisor; zero stops output, 1..1023 divide the selected source; functional completion without waveform timing";
        evidence="manual"; source_ref="R01UH0585EJ0120 pages474-475 Tables12.8-12.9"; behavior="clock";
        trigger="clock-divider"; writable_mask=0x3FF; status_register="CLKD3STAT";
        sync_mask=2; active_mask=1; completion_value=2;
        field { sw=rw; reset=0; } value[31:0];
    } CLKD3DIV @ 0xFFF88818;

    reg {
        regwidth=32; accesswidth=32; desc="EXTCLK1O divider status; SYNC bit1, CLKACT bit0; reserved bits read zero";
        evidence="manual"; source_ref="R01UH0585EJ0120 page475 Table12.9"; behavior="clock";
        field { sw=r; reset=2; } value[31:0];
    } CLKD3STAT @ 0xFFF8881C;

    reg {
        regwidth=32; accesswidth=32; desc="EXTCLK1O source selection; IDs3..6 permitted only with divider stopped and synchronized";
        evidence="manual"; source_ref="R01UH0585EJ0120 pages478-479 Tables12.12-12.13"; behavior="clock";
        trigger="clock-selector"; writable_mask=7; allowed_values="3,4,5,6";
        status_register="CKSC3S"; control_register="CLKD3DIV";
        secondary_status_register="CLKD3STAT"; completion_value=2;
        field { sw=rw; reset=4; } value[31:0];
    } CKSC3C @ 0xFFF890C0;

    reg {
        regwidth=32; accesswidth=32; desc="EXTCLK1O selected-source ID; reserved bits read zero";
        evidence="manual"; source_ref="R01UH0585EJ0120 page479 Table12.13"; behavior="clock";
        field { sw=r; reset=4; } value[31:0];
    } CKSC3S @ 0xFFF890C8;

    reg rsent_rw_t {
        regwidth=32; accesswidth=32; behavior="rsent"; writable_mask=0xFFFFFFFF;
        evidence="manual"; source_ref="R01UH0585EJ0120 section19.3 Tables19.8-19.25";
        reset_classes="power-on,system-1-cvm,system-1-pin,system-2,application-1";
        field { sw=rw; reset=0; } value[31:0];
    };
    reg rsent_ro_t {
        regwidth=32; accesswidth=32; behavior="rsent";
        evidence="manual"; source_ref="R01UH0585EJ0120 section19.3 Tables19.8-19.25";
        reset_classes="power-on,system-1-cvm,system-1-pin,system-2,application-1";
        field { sw=r; reset=0; } value[31:0];
    };
    rsent_rw_t RSENT0TSPC @ 0xFFE05000; RSENT0TSPC->writable_mask=0x17F7F;
    rsent_rw_t RSENT0TSC @ 0xFFE05004;
    rsent_rw_t RSENT0CC @ 0xFFE05010; RSENT0CC->writable_mask=0x1EFF;
    rsent_rw_t RSENT0BRP @ 0xFFE05014; RSENT0BRP->writable_mask=0x0F7F7F1F;
    rsent_rw_t RSENT0IDE @ 0xFFE05018; RSENT0IDE->writable_mask=0x7FF;
    rsent_rw_t RSENT0MDC @ 0xFFE0501C; RSENT0MDC->writable_mask=7;
    rsent_rw_t RSENT0SPCT @ 0xFFE05020; RSENT0SPCT->writable_mask=0x7F;
    rsent_ro_t RSENT0MST @ 0xFFE05024;
    rsent_ro_t RSENT0CS @ 0xFFE05028;
    rsent_rw_t RSENT0CSC @ 0xFFE0502C; RSENT0CSC->writable_mask=0x7FE; RSENT0CSC->read_value=0;
    rsent_ro_t RSENT0SRTS @ 0xFFE05030;
    rsent_ro_t RSENT0SRXD @ 0xFFE05034;
    rsent_ro_t RSENT0CPL @ 0xFFE05038;
    rsent_ro_t RSENT0ML @ 0xFFE0503C;
    rsent_ro_t RSENT0FRTS @ 0xFFE05040;
    rsent_ro_t RSENT0FRXD @ 0xFFE05044;
    rsent_rw_t RSENT1TSPC @ 0xFFE06000; RSENT1TSPC->writable_mask=0x17F7F;
    rsent_rw_t RSENT1TSC @ 0xFFE06004;
    rsent_rw_t RSENT1CC @ 0xFFE06010; RSENT1CC->writable_mask=0x1EFF;
    rsent_rw_t RSENT1BRP @ 0xFFE06014; RSENT1BRP->writable_mask=0x0F7F7F1F;
    rsent_rw_t RSENT1IDE @ 0xFFE06018; RSENT1IDE->writable_mask=0x7FF;
    rsent_rw_t RSENT1MDC @ 0xFFE0601C; RSENT1MDC->writable_mask=7;
    rsent_rw_t RSENT1SPCT @ 0xFFE06020; RSENT1SPCT->writable_mask=0x7F;
    rsent_ro_t RSENT1MST @ 0xFFE06024;
    rsent_ro_t RSENT1CS @ 0xFFE06028;
    rsent_rw_t RSENT1CSC @ 0xFFE0602C; RSENT1CSC->writable_mask=0x7FE; RSENT1CSC->read_value=0;
    rsent_ro_t RSENT1SRTS @ 0xFFE06030;
    rsent_ro_t RSENT1SRXD @ 0xFFE06034;
    rsent_ro_t RSENT1CPL @ 0xFFE06038;
    rsent_ro_t RSENT1ML @ 0xFFE0603C;
    rsent_ro_t RSENT1FRTS @ 0xFFE06040;
    rsent_ro_t RSENT1FRXD @ 0xFFE06044;
    rsent_rw_t RSENTTSSEL @ 0xFFE0F000; RSENTTSSEL->writable_mask=0x777777;
    reg adc_byte_t {
        regwidth=8; accesswidth=8; behavior="adc"; evidence="manual";
        source_ref="R01UH0585EJ0120 section30.3 Tables30.14-30.52";
        reset_classes="power-on,system-1-cvm,system-1-pin,system-2,application-1";
        field { sw=rw; reset=0; } value[7:0];
    };
    reg adc_half_t {
        regwidth=16; accesswidth=16; behavior="adc"; evidence="manual";
        source_ref="R01UH0585EJ0120 Tables30.13,30.29";
        reset_classes="power-on,system-1-cvm,system-1-pin,system-2,application-1";
        field { sw=rw; reset=0; } value[15:0];
    };
    reg adc_word_t {
        regwidth=32; accesswidth=32; behavior="adc"; evidence="manual";
        source_ref="R01UH0585EJ0120 Tables30.10,30.33,30.34,30.50,30.51";
        reset_classes="power-on,system-1-cvm,system-1-pin,system-2,application-1";
        field { sw=rw; reset=0; } value[31:0];
    };
    reg adc_result_t {
        regwidth=32; accesswidth=32; behavior="adc"; evidence="manual";
        source_ref="R01UH0585EJ0120 Tables30.11,30.12 sections30.3.5,30.3.6";
        reset_classes="power-on,system-1-cvm,system-1-pin,system-2,application-1";
        field { sw=r; reset=0; } value[31:0];
    };
    reg adc_status_t {
        regwidth=8; accesswidth=8; behavior="adc"; evidence="manual";
        source_ref="R01UH0585EJ0120 Tables30.36-30.39,30.48,30.49";
        reset_classes="power-on,system-1-cvm,system-1-pin,system-2,application-1";
        field { sw=r; reset=0; } value[7:0];
    };
    reg adc_command_t {
        regwidth=8; accesswidth=8; behavior="adc"; evidence="manual";
        source_ref="R01UH0585EJ0120 sections30.3.2,30.3.3,30.3.8,30.3.15,30.3.16,30.3.18,30.3.19,30.3.29,30.3.34-30.3.36";
        reset_classes="power-on,system-1-cvm,system-1-pin,system-2,application-1";
        read_value=0; writable_mask=1;
        field { sw=w; reset=0; } value[7:0];
    };
    adc_command_t ADCG0ADSYNSTCR @ 0xFFF91300;
    adc_command_t ADCG0ADTSYNSTCR @ 0xFFF91304;

    adc_word_t ADCG0VCR00 @ 0xFFF91000; ADCG0VCR00->writable_mask=0x3E0BF;
    adc_word_t ADCG0VCR01 @ 0xFFF91004; ADCG0VCR01->writable_mask=0x3E0BF;
    adc_word_t ADCG0VCR02 @ 0xFFF91008; ADCG0VCR02->writable_mask=0x3E0BF;
    adc_word_t ADCG0VCR03 @ 0xFFF9100C; ADCG0VCR03->writable_mask=0x3E0BF;
    adc_word_t ADCG0VCR04 @ 0xFFF91010; ADCG0VCR04->writable_mask=0x3E0BF;
    adc_word_t ADCG0VCR05 @ 0xFFF91014; ADCG0VCR05->writable_mask=0x3E0BF;
    adc_word_t ADCG0VCR06 @ 0xFFF91018; ADCG0VCR06->writable_mask=0x3E0BF;
    adc_word_t ADCG0VCR07 @ 0xFFF9101C; ADCG0VCR07->writable_mask=0x3E0BF;
    adc_word_t ADCG0VCR08 @ 0xFFF91020; ADCG0VCR08->writable_mask=0x3E0BF;
    adc_word_t ADCG0VCR09 @ 0xFFF91024; ADCG0VCR09->writable_mask=0x3E0BF;
    adc_word_t ADCG0VCR10 @ 0xFFF91028; ADCG0VCR10->writable_mask=0x3E0BF;
    adc_word_t ADCG0VCR11 @ 0xFFF9102C; ADCG0VCR11->writable_mask=0x3E0BF;
    adc_word_t ADCG0VCR12 @ 0xFFF91030; ADCG0VCR12->writable_mask=0x3E0BF;
    adc_word_t ADCG0VCR13 @ 0xFFF91034; ADCG0VCR13->writable_mask=0x3E0BF;
    adc_word_t ADCG0VCR14 @ 0xFFF91038; ADCG0VCR14->writable_mask=0x3E0BF;
    adc_word_t ADCG0VCR15 @ 0xFFF9103C; ADCG0VCR15->writable_mask=0x3E0BF;
    adc_word_t ADCG0VCR16 @ 0xFFF91040; ADCG0VCR16->writable_mask=0x3E0BF;
    adc_word_t ADCG0VCR17 @ 0xFFF91044; ADCG0VCR17->writable_mask=0x3E0BF;
    adc_word_t ADCG0VCR18 @ 0xFFF91048; ADCG0VCR18->writable_mask=0x3E0BF;
    adc_word_t ADCG0VCR19 @ 0xFFF9104C; ADCG0VCR19->writable_mask=0x3E0BF;
    adc_word_t ADCG0VCR20 @ 0xFFF91050; ADCG0VCR20->writable_mask=0x3E0BF;
    adc_word_t ADCG0VCR21 @ 0xFFF91054; ADCG0VCR21->writable_mask=0x3E0BF;
    adc_word_t ADCG0VCR22 @ 0xFFF91058; ADCG0VCR22->writable_mask=0x3E0BF;
    adc_word_t ADCG0VCR23 @ 0xFFF9105C; ADCG0VCR23->writable_mask=0x3E0BF;
    adc_word_t ADCG1VCR00 @ 0xFFF92000; ADCG1VCR00->writable_mask=0x3E0BF;
    adc_word_t ADCG1VCR01 @ 0xFFF92004; ADCG1VCR01->writable_mask=0x3E0BF;
    adc_word_t ADCG1VCR02 @ 0xFFF92008; ADCG1VCR02->writable_mask=0x3E0BF;
    adc_word_t ADCG1VCR03 @ 0xFFF9200C; ADCG1VCR03->writable_mask=0x3E0BF;
    adc_word_t ADCG1VCR04 @ 0xFFF92010; ADCG1VCR04->writable_mask=0x3E0BF;
    adc_word_t ADCG1VCR05 @ 0xFFF92014; ADCG1VCR05->writable_mask=0x3E0BF;
    adc_word_t ADCG1VCR06 @ 0xFFF92018; ADCG1VCR06->writable_mask=0x3E0BF;
    adc_word_t ADCG1VCR07 @ 0xFFF9201C; ADCG1VCR07->writable_mask=0x3E0BF;
    adc_word_t ADCG1VCR08 @ 0xFFF92020; ADCG1VCR08->writable_mask=0x3E0BF;
    adc_word_t ADCG1VCR09 @ 0xFFF92024; ADCG1VCR09->writable_mask=0x3E0BF;
    adc_word_t ADCG1VCR10 @ 0xFFF92028; ADCG1VCR10->writable_mask=0x3E0BF;
    adc_word_t ADCG1VCR11 @ 0xFFF9202C; ADCG1VCR11->writable_mask=0x3E0BF;
    adc_word_t ADCG1VCR12 @ 0xFFF92030; ADCG1VCR12->writable_mask=0x3E0BF;
    adc_word_t ADCG1VCR13 @ 0xFFF92034; ADCG1VCR13->writable_mask=0x3E0BF;
    adc_word_t ADCG1VCR14 @ 0xFFF92038; ADCG1VCR14->writable_mask=0x3E0BF;
    adc_word_t ADCG1VCR15 @ 0xFFF9203C; ADCG1VCR15->writable_mask=0x3E0BF;
    adc_word_t ADCG1VCR16 @ 0xFFF92040; ADCG1VCR16->writable_mask=0x3E0BF;
    adc_word_t ADCG1VCR17 @ 0xFFF92044; ADCG1VCR17->writable_mask=0x3E0BF;
    adc_word_t ADCG1VCR18 @ 0xFFF92048; ADCG1VCR18->writable_mask=0x3E0BF;
    adc_word_t ADCG1VCR19 @ 0xFFF9204C; ADCG1VCR19->writable_mask=0x3E0BF;
    adc_word_t ADCG1VCR20 @ 0xFFF92050; ADCG1VCR20->writable_mask=0x3E0BF;
    adc_word_t ADCG1VCR21 @ 0xFFF92054; ADCG1VCR21->writable_mask=0x3E0BF;
    adc_word_t ADCG1VCR22 @ 0xFFF92058; ADCG1VCR22->writable_mask=0x3E0BF;
    adc_word_t ADCG1VCR23 @ 0xFFF9205C; ADCG1VCR23->writable_mask=0x3E0BF;

    adc_result_t ADCG0DR00 @ 0xFFF91100; ADCG0DR00->accesswidth=16; ADCG0DR00->access_widths="2,4";
    adc_result_t ADCG0DR02 @ 0xFFF91104; ADCG0DR02->accesswidth=16; ADCG0DR02->access_widths="2,4";
    adc_result_t ADCG0DR04 @ 0xFFF91108; ADCG0DR04->accesswidth=16; ADCG0DR04->access_widths="2,4";
    adc_result_t ADCG0DR06 @ 0xFFF9110C; ADCG0DR06->accesswidth=16; ADCG0DR06->access_widths="2,4";
    adc_result_t ADCG0DR08 @ 0xFFF91110; ADCG0DR08->accesswidth=16; ADCG0DR08->access_widths="2,4";
    adc_result_t ADCG0DR10 @ 0xFFF91114; ADCG0DR10->accesswidth=16; ADCG0DR10->access_widths="2,4";
    adc_result_t ADCG0DR12 @ 0xFFF91118; ADCG0DR12->accesswidth=16; ADCG0DR12->access_widths="2,4";
    adc_result_t ADCG0DR14 @ 0xFFF9111C; ADCG0DR14->accesswidth=16; ADCG0DR14->access_widths="2,4";
    adc_result_t ADCG0DR16 @ 0xFFF91120; ADCG0DR16->accesswidth=16; ADCG0DR16->access_widths="2,4";
    adc_result_t ADCG0DR18 @ 0xFFF91124; ADCG0DR18->accesswidth=16; ADCG0DR18->access_widths="2,4";
    adc_result_t ADCG0DR20 @ 0xFFF91128; ADCG0DR20->accesswidth=16; ADCG0DR20->access_widths="2,4";
    adc_result_t ADCG0DR22 @ 0xFFF9112C; ADCG0DR22->accesswidth=16; ADCG0DR22->access_widths="2,4";
    adc_result_t ADCG1DR00 @ 0xFFF92100; ADCG1DR00->accesswidth=16; ADCG1DR00->access_widths="2,4";
    adc_result_t ADCG1DR02 @ 0xFFF92104; ADCG1DR02->accesswidth=16; ADCG1DR02->access_widths="2,4";
    adc_result_t ADCG1DR04 @ 0xFFF92108; ADCG1DR04->accesswidth=16; ADCG1DR04->access_widths="2,4";
    adc_result_t ADCG1DR06 @ 0xFFF9210C; ADCG1DR06->accesswidth=16; ADCG1DR06->access_widths="2,4";
    adc_result_t ADCG1DR08 @ 0xFFF92110; ADCG1DR08->accesswidth=16; ADCG1DR08->access_widths="2,4";
    adc_result_t ADCG1DR10 @ 0xFFF92114; ADCG1DR10->accesswidth=16; ADCG1DR10->access_widths="2,4";
    adc_result_t ADCG1DR12 @ 0xFFF92118; ADCG1DR12->accesswidth=16; ADCG1DR12->access_widths="2,4";
    adc_result_t ADCG1DR14 @ 0xFFF9211C; ADCG1DR14->accesswidth=16; ADCG1DR14->access_widths="2,4";
    adc_result_t ADCG1DR16 @ 0xFFF92120; ADCG1DR16->accesswidth=16; ADCG1DR16->access_widths="2,4";
    adc_result_t ADCG1DR18 @ 0xFFF92124; ADCG1DR18->accesswidth=16; ADCG1DR18->access_widths="2,4";
    adc_result_t ADCG1DR20 @ 0xFFF92128; ADCG1DR20->accesswidth=16; ADCG1DR20->access_widths="2,4";
    adc_result_t ADCG1DR22 @ 0xFFF9212C; ADCG1DR22->accesswidth=16; ADCG1DR22->access_widths="2,4";
    adc_result_t ADCG0DIR00 @ 0xFFF91200;
    adc_result_t ADCG0DIR01 @ 0xFFF91204;
    adc_result_t ADCG0DIR02 @ 0xFFF91208;
    adc_result_t ADCG0DIR03 @ 0xFFF9120C;
    adc_result_t ADCG0DIR04 @ 0xFFF91210;
    adc_result_t ADCG0DIR05 @ 0xFFF91214;
    adc_result_t ADCG0DIR06 @ 0xFFF91218;
    adc_result_t ADCG0DIR07 @ 0xFFF9121C;
    adc_result_t ADCG0DIR08 @ 0xFFF91220;
    adc_result_t ADCG0DIR09 @ 0xFFF91224;
    adc_result_t ADCG0DIR10 @ 0xFFF91228;
    adc_result_t ADCG0DIR11 @ 0xFFF9122C;
    adc_result_t ADCG0DIR12 @ 0xFFF91230;
    adc_result_t ADCG0DIR13 @ 0xFFF91234;
    adc_result_t ADCG0DIR14 @ 0xFFF91238;
    adc_result_t ADCG0DIR15 @ 0xFFF9123C;
    adc_result_t ADCG0DIR16 @ 0xFFF91240;
    adc_result_t ADCG0DIR17 @ 0xFFF91244;
    adc_result_t ADCG0DIR18 @ 0xFFF91248;
    adc_result_t ADCG0DIR19 @ 0xFFF9124C;
    adc_result_t ADCG0DIR20 @ 0xFFF91250;
    adc_result_t ADCG0DIR21 @ 0xFFF91254;
    adc_result_t ADCG0DIR22 @ 0xFFF91258;
    adc_result_t ADCG0DIR23 @ 0xFFF9125C;
    adc_result_t ADCG1DIR00 @ 0xFFF92200;
    adc_result_t ADCG1DIR01 @ 0xFFF92204;
    adc_result_t ADCG1DIR02 @ 0xFFF92208;
    adc_result_t ADCG1DIR03 @ 0xFFF9220C;
    adc_result_t ADCG1DIR04 @ 0xFFF92210;
    adc_result_t ADCG1DIR05 @ 0xFFF92214;
    adc_result_t ADCG1DIR06 @ 0xFFF92218;
    adc_result_t ADCG1DIR07 @ 0xFFF9221C;
    adc_result_t ADCG1DIR08 @ 0xFFF92220;
    adc_result_t ADCG1DIR09 @ 0xFFF92224;
    adc_result_t ADCG1DIR10 @ 0xFFF92228;
    adc_result_t ADCG1DIR11 @ 0xFFF9222C;
    adc_result_t ADCG1DIR12 @ 0xFFF92230;
    adc_result_t ADCG1DIR13 @ 0xFFF92234;
    adc_result_t ADCG1DIR14 @ 0xFFF92238;
    adc_result_t ADCG1DIR15 @ 0xFFF9223C;
    adc_result_t ADCG1DIR16 @ 0xFFF92240;
    adc_result_t ADCG1DIR17 @ 0xFFF92244;
    adc_result_t ADCG1DIR18 @ 0xFFF92248;
    adc_result_t ADCG1DIR19 @ 0xFFF9224C;
    adc_result_t ADCG1DIR20 @ 0xFFF92250;
    adc_result_t ADCG1DIR21 @ 0xFFF92254;
    adc_result_t ADCG1DIR22 @ 0xFFF92258;
    adc_result_t ADCG1DIR23 @ 0xFFF9225C;

    adc_half_t ADCG0SMPCR @ 0xFFF91340; ADCG0SMPCR->writable_mask=0xFFFF;
    adc_half_t ADCG1SMPCR @ 0xFFF92340; ADCG1SMPCR->writable_mask=0xFFFF;
    adc_command_t ADCG0ADHALTR @ 0xFFF91380;
    adc_command_t ADCG1ADHALTR @ 0xFFF92380;
    adc_byte_t ADCG0ADCR1 @ 0xFFF91384; ADCG0ADCR1->writable_mask=3;
    adc_byte_t ADCG1ADCR1 @ 0xFFF92384; ADCG1ADCR1->writable_mask=3;
    adc_byte_t ADCG0ADCR2 @ 0xFFF91398; ADCG0ADCR2->writable_mask=0x11;
    adc_byte_t ADCG1ADCR2 @ 0xFFF92398; ADCG1ADCR2->writable_mask=0x11;
    adc_byte_t ADCG0SFTCR @ 0xFFF913C0; ADCG0SFTCR->writable_mask=0x1F;
    adc_byte_t ADCG1SFTCR @ 0xFFF923C0; ADCG1SFTCR->writable_mask=0x1F;
    adc_byte_t ADCG0TDCR @ 0xFFF913C4; ADCG0TDCR->writable_mask=0x83;
    adc_byte_t ADCG1TDCR @ 0xFFF923C4; ADCG1TDCR->writable_mask=0x83;
    adc_word_t ADCG0ODCR @ 0xFFF913C8; ADCG0ODCR->writable_mask=0x800000BF;
    adc_word_t ADCG1ODCR @ 0xFFF923C8; ADCG1ODCR->writable_mask=0x800000BF;
    adc_word_t ADCG0ULLMTBR0 @ 0xFFF913CC; ADCG0ULLMTBR0->writable_mask=0x7FFE7FFE; ADCG0ULLMTBR0.value->reset=0x7FFE0000;
    adc_word_t ADCG0ULLMTBR1 @ 0xFFF913D0; ADCG0ULLMTBR1->writable_mask=0x7FFE7FFE; ADCG0ULLMTBR1.value->reset=0x7FFE0000;
    adc_word_t ADCG0ULLMTBR2 @ 0xFFF913D4; ADCG0ULLMTBR2->writable_mask=0x7FFE7FFE; ADCG0ULLMTBR2.value->reset=0x7FFE0000;
    adc_word_t ADCG1ULLMTBR0 @ 0xFFF923CC; ADCG1ULLMTBR0->writable_mask=0x7FFE7FFE; ADCG1ULLMTBR0.value->reset=0x7FFE0000;
    adc_word_t ADCG1ULLMTBR1 @ 0xFFF923D0; ADCG1ULLMTBR1->writable_mask=0x7FFE7FFE; ADCG1ULLMTBR1.value->reset=0x7FFE0000;
    adc_word_t ADCG1ULLMTBR2 @ 0xFFF923D4; ADCG1ULLMTBR2->writable_mask=0x7FFE7FFE; ADCG1ULLMTBR2.value->reset=0x7FFE0000;
    adc_command_t ADCG0ECR @ 0xFFF913D8; ADCG0ECR->writable_mask=0xF;
    adc_command_t ADCG1ECR @ 0xFFF923D8; ADCG1ECR->writable_mask=0xF;
    adc_status_t ADCG0ULER @ 0xFFF913DC;
    adc_status_t ADCG0OWER @ 0xFFF913E0;
    adc_status_t ADCG0PER @ 0xFFF913E4;
    adc_status_t ADCG0IDER @ 0xFFF913E8;
    adc_status_t ADCG1ULER @ 0xFFF923DC;
    adc_status_t ADCG1OWER @ 0xFFF923E0;
    adc_status_t ADCG1PER @ 0xFFF923E4;
    adc_status_t ADCG1IDER @ 0xFFF923E8;
    adc_command_t ADCG0THSMPSTCR @ 0xFFF91400;
    adc_command_t ADCG1THSMPSTCR @ 0xFFF92400;
    adc_command_t ADCG0THSTPCR @ 0xFFF91404;
    adc_command_t ADCG1THSTPCR @ 0xFFF92404;
    adc_byte_t ADCG0THCR @ 0xFFF91408; ADCG0THCR->writable_mask=1;
    adc_byte_t ADCG1THCR @ 0xFFF92408; ADCG1THCR->writable_mask=1;
    adc_command_t ADCG0THAHLDSTCR @ 0xFFF91410;
    adc_command_t ADCG1THAHLDSTCR @ 0xFFF92410;
    adc_command_t ADCG0THBHLDSTCR @ 0xFFF91414;
    adc_command_t ADCG1THBHLDSTCR @ 0xFFF92414;
    adc_byte_t ADCG0THACR @ 0xFFF91420; ADCG0THACR->writable_mask=0x33;
    adc_byte_t ADCG1THACR @ 0xFFF92420; ADCG1THACR->writable_mask=0x33;
    adc_byte_t ADCG0THBCR @ 0xFFF91424; ADCG0THBCR->writable_mask=0x33;
    adc_byte_t ADCG1THBCR @ 0xFFF92424; ADCG1THBCR->writable_mask=0x33;
    adc_byte_t ADCG0THER @ 0xFFF91430; ADCG0THER->writable_mask=0x3F;
    adc_byte_t ADCG1THER @ 0xFFF92430; ADCG1THER->writable_mask=0xF;
    adc_half_t ADCG0THGSR @ 0xFFF91434; ADCG0THGSR->writable_mask=0x555;
    adc_half_t ADCG1THGSR @ 0xFFF92434; ADCG1THGSR->writable_mask=0x55;
    adc_word_t ADOPDIG0 @ 0xFFF91800; ADOPDIG0->writable_mask=0xFFF;
    adc_word_t ADOPDIG1 @ 0xFFF92800; ADOPDIG1->writable_mask=0xFFF;

    adc_command_t ADCG0SGSTCR0 @ 0xFFF91480;
    adc_byte_t ADCG0SGCR0 @ 0xFFF91490; ADCG0SGCR0->writable_mask=0x71;
    adc_byte_t ADCG0SGVCSP0 @ 0xFFF91494; ADCG0SGVCSP0->writable_mask=0x3F;
    adc_byte_t ADCG0SGVCEP0 @ 0xFFF91498; ADCG0SGVCEP0->writable_mask=0x3F;
    adc_byte_t ADCG0SGMCYCR0 @ 0xFFF9149C; ADCG0SGMCYCR0->writable_mask=0xFF;
    adc_status_t ADCG0SGSR0 @ 0xFFF914A4;
    adc_byte_t ADCG0ULLMSR0 @ 0xFFF914B0; ADCG0ULLMSR0->writable_mask=3;
    adc_command_t ADCG0SGSTCR1 @ 0xFFF91500;
    adc_byte_t ADCG0SGCR1 @ 0xFFF91510; ADCG0SGCR1->writable_mask=0x71;
    adc_byte_t ADCG0SGVCSP1 @ 0xFFF91514; ADCG0SGVCSP1->writable_mask=0x3F;
    adc_byte_t ADCG0SGVCEP1 @ 0xFFF91518; ADCG0SGVCEP1->writable_mask=0x3F;
    adc_byte_t ADCG0SGMCYCR1 @ 0xFFF9151C; ADCG0SGMCYCR1->writable_mask=0xFF;
    adc_status_t ADCG0SGSR1 @ 0xFFF91524;
    adc_byte_t ADCG0ULLMSR1 @ 0xFFF91530; ADCG0ULLMSR1->writable_mask=3;
    adc_command_t ADCG0SGSTCR2 @ 0xFFF91580;
    adc_byte_t ADCG0SGCR2 @ 0xFFF91590; ADCG0SGCR2->writable_mask=0x71;
    adc_byte_t ADCG0SGVCSP2 @ 0xFFF91594; ADCG0SGVCSP2->writable_mask=0x3F;
    adc_byte_t ADCG0SGVCEP2 @ 0xFFF91598; ADCG0SGVCEP2->writable_mask=0x3F;
    adc_byte_t ADCG0SGMCYCR2 @ 0xFFF9159C; ADCG0SGMCYCR2->writable_mask=0xFF;
    adc_status_t ADCG0SGSR2 @ 0xFFF915A4;
    adc_byte_t ADCG0ULLMSR2 @ 0xFFF915B0; ADCG0ULLMSR2->writable_mask=3;
    adc_command_t ADCG0SGSTCR3 @ 0xFFF91600;
    adc_command_t ADCG0ADTSTCR3 @ 0xFFF91608;
    adc_command_t ADCG0ADTENDCR3 @ 0xFFF9160C;
    adc_byte_t ADCG0SGCR3 @ 0xFFF91610; ADCG0SGCR3->writable_mask=0xF3;
    adc_byte_t ADCG0SGVCSP3 @ 0xFFF91614; ADCG0SGVCSP3->writable_mask=0x3F;
    adc_byte_t ADCG0SGVCEP3 @ 0xFFF91618; ADCG0SGVCEP3->writable_mask=0x3F;
    adc_byte_t ADCG0SGMCYCR3 @ 0xFFF9161C; ADCG0SGMCYCR3->writable_mask=0xFF;
    adc_status_t ADCG0SGSR3 @ 0xFFF91624;
    adc_word_t ADCG0ADTIPR3 @ 0xFFF91628; ADCG0ADTIPR3->writable_mask=0x1FFFFF;
    adc_word_t ADCG0ADTPRR3 @ 0xFFF9162C; ADCG0ADTPRR3->writable_mask=0x1FFFFF; ADCG0ADTPRR3.value->reset=0x1FFFFF;
    adc_byte_t ADCG0ULLMSR3 @ 0xFFF91630; ADCG0ULLMSR3->writable_mask=3;
    adc_command_t ADCG0SGSTCR4 @ 0xFFF91680;
    adc_command_t ADCG0ADTSTCR4 @ 0xFFF91688;
    adc_command_t ADCG0ADTENDCR4 @ 0xFFF9168C;
    adc_byte_t ADCG0SGCR4 @ 0xFFF91690; ADCG0SGCR4->writable_mask=0xF3;
    adc_byte_t ADCG0SGVCSP4 @ 0xFFF91694; ADCG0SGVCSP4->writable_mask=0x3F;
    adc_byte_t ADCG0SGVCEP4 @ 0xFFF91698; ADCG0SGVCEP4->writable_mask=0x3F;
    adc_byte_t ADCG0SGMCYCR4 @ 0xFFF9169C; ADCG0SGMCYCR4->writable_mask=0xFF;
    adc_status_t ADCG0SGSR4 @ 0xFFF916A4;
    adc_word_t ADCG0ADTIPR4 @ 0xFFF916A8; ADCG0ADTIPR4->writable_mask=0x1FFFFF;
    adc_word_t ADCG0ADTPRR4 @ 0xFFF916AC; ADCG0ADTPRR4->writable_mask=0x1FFFFF; ADCG0ADTPRR4.value->reset=0x1FFFFF;
    adc_byte_t ADCG0ULLMSR4 @ 0xFFF916B0; ADCG0ULLMSR4->writable_mask=3;
    adc_command_t ADCG1SGSTCR0 @ 0xFFF92480;
    adc_byte_t ADCG1SGCR0 @ 0xFFF92490; ADCG1SGCR0->writable_mask=0x71;
    adc_byte_t ADCG1SGVCSP0 @ 0xFFF92494; ADCG1SGVCSP0->writable_mask=0x3F;
    adc_byte_t ADCG1SGVCEP0 @ 0xFFF92498; ADCG1SGVCEP0->writable_mask=0x3F;
    adc_byte_t ADCG1SGMCYCR0 @ 0xFFF9249C; ADCG1SGMCYCR0->writable_mask=0xFF;
    adc_status_t ADCG1SGSR0 @ 0xFFF924A4;
    adc_byte_t ADCG1ULLMSR0 @ 0xFFF924B0; ADCG1ULLMSR0->writable_mask=3;
    adc_command_t ADCG1SGSTCR1 @ 0xFFF92500;
    adc_byte_t ADCG1SGCR1 @ 0xFFF92510; ADCG1SGCR1->writable_mask=0x71;
    adc_byte_t ADCG1SGVCSP1 @ 0xFFF92514; ADCG1SGVCSP1->writable_mask=0x3F;
    adc_byte_t ADCG1SGVCEP1 @ 0xFFF92518; ADCG1SGVCEP1->writable_mask=0x3F;
    adc_byte_t ADCG1SGMCYCR1 @ 0xFFF9251C; ADCG1SGMCYCR1->writable_mask=0xFF;
    adc_status_t ADCG1SGSR1 @ 0xFFF92524;
    adc_byte_t ADCG1ULLMSR1 @ 0xFFF92530; ADCG1ULLMSR1->writable_mask=3;
    adc_command_t ADCG1SGSTCR2 @ 0xFFF92580;
    adc_byte_t ADCG1SGCR2 @ 0xFFF92590; ADCG1SGCR2->writable_mask=0x71;
    adc_byte_t ADCG1SGVCSP2 @ 0xFFF92594; ADCG1SGVCSP2->writable_mask=0x3F;
    adc_byte_t ADCG1SGVCEP2 @ 0xFFF92598; ADCG1SGVCEP2->writable_mask=0x3F;
    adc_byte_t ADCG1SGMCYCR2 @ 0xFFF9259C; ADCG1SGMCYCR2->writable_mask=0xFF;
    adc_status_t ADCG1SGSR2 @ 0xFFF925A4;
    adc_byte_t ADCG1ULLMSR2 @ 0xFFF925B0; ADCG1ULLMSR2->writable_mask=3;
    adc_command_t ADCG1SGSTCR3 @ 0xFFF92600;
    adc_command_t ADCG1ADTSTCR3 @ 0xFFF92608;
    adc_command_t ADCG1ADTENDCR3 @ 0xFFF9260C;
    adc_byte_t ADCG1SGCR3 @ 0xFFF92610; ADCG1SGCR3->writable_mask=0xF3;
    adc_byte_t ADCG1SGVCSP3 @ 0xFFF92614; ADCG1SGVCSP3->writable_mask=0x3F;
    adc_byte_t ADCG1SGVCEP3 @ 0xFFF92618; ADCG1SGVCEP3->writable_mask=0x3F;
    adc_byte_t ADCG1SGMCYCR3 @ 0xFFF9261C; ADCG1SGMCYCR3->writable_mask=0xFF;
    adc_status_t ADCG1SGSR3 @ 0xFFF92624;
    adc_word_t ADCG1ADTIPR3 @ 0xFFF92628; ADCG1ADTIPR3->writable_mask=0x1FFFFF;
    adc_word_t ADCG1ADTPRR3 @ 0xFFF9262C; ADCG1ADTPRR3->writable_mask=0x1FFFFF; ADCG1ADTPRR3.value->reset=0x1FFFFF;
    adc_byte_t ADCG1ULLMSR3 @ 0xFFF92630; ADCG1ULLMSR3->writable_mask=3;
    adc_command_t ADCG1SGSTCR4 @ 0xFFF92680;
    adc_command_t ADCG1ADTSTCR4 @ 0xFFF92688;
    adc_command_t ADCG1ADTENDCR4 @ 0xFFF9268C;
    adc_byte_t ADCG1SGCR4 @ 0xFFF92690; ADCG1SGCR4->writable_mask=0xF3;
    adc_byte_t ADCG1SGVCSP4 @ 0xFFF92694; ADCG1SGVCSP4->writable_mask=0x3F;
    adc_byte_t ADCG1SGVCEP4 @ 0xFFF92698; ADCG1SGVCEP4->writable_mask=0x3F;
    adc_byte_t ADCG1SGMCYCR4 @ 0xFFF9269C; ADCG1SGMCYCR4->writable_mask=0xFF;
    adc_status_t ADCG1SGSR4 @ 0xFFF926A4;
    adc_word_t ADCG1ADTIPR4 @ 0xFFF926A8; ADCG1ADTIPR4->writable_mask=0x1FFFFF;
    adc_word_t ADCG1ADTPRR4 @ 0xFFF926AC; ADCG1ADTPRR4->writable_mask=0x1FFFFF; ADCG1ADTPRR4.value->reset=0x1FFFFF;
    adc_byte_t ADCG1ULLMSR4 @ 0xFFF926B0; ADCG1ULLMSR4->writable_mask=3;
    reg {
        regwidth=32; accesswidth=32; behavior="adc-clock"; evidence="manual";
        source_ref="R01UH0585EJ0120 Table12.14"; writable_mask=6;
        reset_classes="power-on,system-1-cvm,system-1-pin,system-2,application-1";
        field { sw=rw; reset=2; } value[31:0];
    } CKSC8C @ 0xFFF89110;
    reg {
        regwidth=32; accesswidth=32; behavior="adc-clock"; evidence="manual";
        source_ref="R01UH0585EJ0120 Table12.15";
        reset_classes="power-on,system-1-cvm,system-1-pin,system-2,application-1";
        field { sw=r; reset=3; } value[31:0];
    } CKSC8S @ 0xFFF89114;



    // Table6.11 implemented channels only; gaps are reserved, not register arrays.
    reg intc_edge_t {
        regwidth=16; accesswidth=16; access_widths="1,2";
        behavior="intc_eic"; writable_mask=0x10CF;
        desc="EI interrupt control; synchronous edge EIRF is software writable and clears on acceptance; EICT/reserved bits read reset";
        evidence="manual"; source_ref="R01UH0585EJ0120 section6.2.2 Table6.4 and Table6.11";
        field { sw=rw; reset=0x008F; } value[15:0];
    };
    reg intc_level_t {
        regwidth=16; accesswidth=16; access_widths="1,2";
        behavior="intc_eic"; writable_mask=0xCF;
        desc="EI interrupt control; high-level EIRF is read-only and follows its source; EICT/reserved bits read reset";
        evidence="manual"; source_ref="R01UH0585EJ0120 section6.2.2 Table6.4 and Table6.11";
        field { sw=rw; reset=0x808F; } value[15:0];
    };
    intc_edge_t EIC9 @ 0xFFFEEA12; EIC9->interrupt_channel=9;
    intc_edge_t EIC16 @ 0xFFFEEA20; EIC16->interrupt_channel=16;
    intc_edge_t EIC17 @ 0xFFFEEA22; EIC17->interrupt_channel=17;
    intc_edge_t EIC18 @ 0xFFFEEA24; EIC18->interrupt_channel=18;
    intc_edge_t EIC19 @ 0xFFFEEA26; EIC19->interrupt_channel=19;
    intc_edge_t EIC20 @ 0xFFFEEA28; EIC20->interrupt_channel=20;
    intc_edge_t EIC21 @ 0xFFFEEA2A; EIC21->interrupt_channel=21;
    intc_edge_t EIC22 @ 0xFFFEEA2C; EIC22->interrupt_channel=22;
    intc_edge_t EIC23 @ 0xFFFEEA2E; EIC23->interrupt_channel=23;
    intc_edge_t EIC24 @ 0xFFFEEA30; EIC24->interrupt_channel=24;
    intc_edge_t EIC25 @ 0xFFFEEA32; EIC25->interrupt_channel=25;
    intc_edge_t EIC26 @ 0xFFFEEA34; EIC26->interrupt_channel=26;
    intc_edge_t EIC27 @ 0xFFFEEA36; EIC27->interrupt_channel=27;
    intc_edge_t EIC28 @ 0xFFFEEA38; EIC28->interrupt_channel=28;
    intc_edge_t EIC29 @ 0xFFFEEA3A; EIC29->interrupt_channel=29;
    intc_edge_t EIC30 @ 0xFFFEEA3C; EIC30->interrupt_channel=30;
    intc_edge_t EIC31 @ 0xFFFEEA3E; EIC31->interrupt_channel=31;
    intc_edge_t EIC32 @ 0xFFFFB040; EIC32->interrupt_channel=32;
    intc_edge_t EIC33 @ 0xFFFFB042; EIC33->interrupt_channel=33;
    intc_edge_t EIC34 @ 0xFFFFB044; EIC34->interrupt_channel=34;
    intc_edge_t EIC35 @ 0xFFFFB046; EIC35->interrupt_channel=35;
    intc_edge_t EIC36 @ 0xFFFFB048; EIC36->interrupt_channel=36;
    intc_edge_t EIC40 @ 0xFFFFB050; EIC40->interrupt_channel=40;
    intc_edge_t EIC41 @ 0xFFFFB052; EIC41->interrupt_channel=41;
    intc_edge_t EIC42 @ 0xFFFFB054; EIC42->interrupt_channel=42;
    intc_edge_t EIC43 @ 0xFFFFB056; EIC43->interrupt_channel=43;
    intc_edge_t EIC44 @ 0xFFFFB058; EIC44->interrupt_channel=44;
    intc_edge_t EIC45 @ 0xFFFFB05A; EIC45->interrupt_channel=45;
    intc_edge_t EIC46 @ 0xFFFFB05C; EIC46->interrupt_channel=46;
    intc_edge_t EIC47 @ 0xFFFFB05E; EIC47->interrupt_channel=47;
    intc_edge_t EIC48 @ 0xFFFFB060; EIC48->interrupt_channel=48;
    intc_edge_t EIC49 @ 0xFFFFB062; EIC49->interrupt_channel=49;
    intc_edge_t EIC50 @ 0xFFFFB064; EIC50->interrupt_channel=50;
    intc_edge_t EIC51 @ 0xFFFFB066; EIC51->interrupt_channel=51;
    intc_edge_t EIC52 @ 0xFFFFB068; EIC52->interrupt_channel=52;
    intc_edge_t EIC53 @ 0xFFFFB06A; EIC53->interrupt_channel=53;
    intc_edge_t EIC54 @ 0xFFFFB06C; EIC54->interrupt_channel=54;
    intc_edge_t EIC55 @ 0xFFFFB06E; EIC55->interrupt_channel=55;
    intc_edge_t EIC56 @ 0xFFFFB070; EIC56->interrupt_channel=56;
    intc_edge_t EIC57 @ 0xFFFFB072; EIC57->interrupt_channel=57;
    intc_edge_t EIC58 @ 0xFFFFB074; EIC58->interrupt_channel=58;
    intc_edge_t EIC59 @ 0xFFFFB076; EIC59->interrupt_channel=59;
    intc_edge_t EIC60 @ 0xFFFFB078; EIC60->interrupt_channel=60;
    intc_edge_t EIC61 @ 0xFFFFB07A; EIC61->interrupt_channel=61;
    intc_edge_t EIC62 @ 0xFFFFB07C; EIC62->interrupt_channel=62;
    intc_edge_t EIC63 @ 0xFFFFB07E; EIC63->interrupt_channel=63;
    intc_edge_t EIC64 @ 0xFFFFB080; EIC64->interrupt_channel=64;
    intc_edge_t EIC65 @ 0xFFFFB082; EIC65->interrupt_channel=65;
    intc_edge_t EIC66 @ 0xFFFFB084; EIC66->interrupt_channel=66;
    intc_edge_t EIC67 @ 0xFFFFB086; EIC67->interrupt_channel=67;
    intc_edge_t EIC68 @ 0xFFFFB088; EIC68->interrupt_channel=68;
    intc_edge_t EIC69 @ 0xFFFFB08A; EIC69->interrupt_channel=69;
    intc_edge_t EIC70 @ 0xFFFFB08C; EIC70->interrupt_channel=70;
    intc_edge_t EIC71 @ 0xFFFFB08E; EIC71->interrupt_channel=71;
    intc_edge_t EIC72 @ 0xFFFFB090; EIC72->interrupt_channel=72;
    intc_edge_t EIC73 @ 0xFFFFB092; EIC73->interrupt_channel=73;
    intc_edge_t EIC74 @ 0xFFFFB094; EIC74->interrupt_channel=74;
    intc_edge_t EIC75 @ 0xFFFFB096; EIC75->interrupt_channel=75;
    intc_edge_t EIC76 @ 0xFFFFB098; EIC76->interrupt_channel=76;
    intc_edge_t EIC77 @ 0xFFFFB09A; EIC77->interrupt_channel=77;
    intc_edge_t EIC78 @ 0xFFFFB09C; EIC78->interrupt_channel=78;
    intc_edge_t EIC79 @ 0xFFFFB09E; EIC79->interrupt_channel=79;
    intc_edge_t EIC80 @ 0xFFFFB0A0; EIC80->interrupt_channel=80;
    intc_edge_t EIC81 @ 0xFFFFB0A2; EIC81->interrupt_channel=81;
    // CSIH request pulses use the existing edge-latched INTC arbiter (Table14.7).
    intc_edge_t EIC82 @ 0xFFFFB0A4; EIC82->interrupt_channel=82;
    intc_edge_t EIC83 @ 0xFFFFB0A6; EIC83->interrupt_channel=83;
    intc_edge_t EIC84 @ 0xFFFFB0A8; EIC84->interrupt_channel=84;
    intc_edge_t EIC85 @ 0xFFFFB0AA; EIC85->interrupt_channel=85;
    intc_edge_t EIC86 @ 0xFFFFB0AC; EIC86->interrupt_channel=86;
    intc_edge_t EIC87 @ 0xFFFFB0AE; EIC87->interrupt_channel=87;
    intc_edge_t EIC88 @ 0xFFFFB0B0; EIC88->interrupt_channel=88;
    intc_edge_t EIC89 @ 0xFFFFB0B2; EIC89->interrupt_channel=89;
    intc_edge_t EIC90 @ 0xFFFFB0B4; EIC90->interrupt_channel=90;
    intc_edge_t EIC91 @ 0xFFFFB0B6; EIC91->interrupt_channel=91;
    intc_edge_t EIC92 @ 0xFFFFB0B8; EIC92->interrupt_channel=92;
    intc_edge_t EIC93 @ 0xFFFFB0BA; EIC93->interrupt_channel=93;
    intc_edge_t EIC94 @ 0xFFFFB0BC; EIC94->interrupt_channel=94;
    intc_edge_t EIC95 @ 0xFFFFB0BE; EIC95->interrupt_channel=95;
    intc_edge_t EIC96 @ 0xFFFFB0C0; EIC96->interrupt_channel=96;
    intc_edge_t EIC97 @ 0xFFFFB0C2; EIC97->interrupt_channel=97;
    intc_edge_t EIC98 @ 0xFFFFB0C4; EIC98->interrupt_channel=98;
    intc_edge_t EIC99 @ 0xFFFFB0C6; EIC99->interrupt_channel=99;
    intc_edge_t EIC100 @ 0xFFFFB0C8; EIC100->interrupt_channel=100;
    intc_edge_t EIC101 @ 0xFFFFB0CA; EIC101->interrupt_channel=101;
    intc_edge_t EIC102 @ 0xFFFFB0CC; EIC102->interrupt_channel=102;
    intc_edge_t EIC103 @ 0xFFFFB0CE; EIC103->interrupt_channel=103;
    intc_edge_t EIC104 @ 0xFFFFB0D0; EIC104->interrupt_channel=104;
    intc_edge_t EIC105 @ 0xFFFFB0D2; EIC105->interrupt_channel=105;
    intc_level_t EIC106 @ 0xFFFFB0D4; EIC106->interrupt_channel=106;
    intc_edge_t EIC107 @ 0xFFFFB0D6; EIC107->interrupt_channel=107;
    intc_edge_t EIC108 @ 0xFFFFB0D8; EIC108->interrupt_channel=108;
    intc_level_t EIC109 @ 0xFFFFB0DA; EIC109->interrupt_channel=109;
    intc_level_t EIC110 @ 0xFFFFB0DC; EIC110->interrupt_channel=110;
    intc_edge_t EIC111 @ 0xFFFFB0DE; EIC111->interrupt_channel=111;
    intc_edge_t EIC112 @ 0xFFFFB0E0; EIC112->interrupt_channel=112;
    intc_level_t EIC113 @ 0xFFFFB0E2; EIC113->interrupt_channel=113;
    intc_edge_t EIC114 @ 0xFFFFB0E4; EIC114->interrupt_channel=114;
    intc_edge_t EIC115 @ 0xFFFFB0E6; EIC115->interrupt_channel=115;
    intc_edge_t EIC116 @ 0xFFFFB0E8; EIC116->interrupt_channel=116;
    intc_edge_t EIC117 @ 0xFFFFB0EA; EIC117->interrupt_channel=117;
    intc_edge_t EIC118 @ 0xFFFFB0EC; EIC118->interrupt_channel=118;
    intc_edge_t EIC119 @ 0xFFFFB0EE; EIC119->interrupt_channel=119;
    intc_level_t EIC120 @ 0xFFFFB0F0; EIC120->interrupt_channel=120;
    intc_level_t EIC121 @ 0xFFFFB0F2; EIC121->interrupt_channel=121;
    intc_edge_t EIC128 @ 0xFFFFB100; EIC128->interrupt_channel=128;
    intc_edge_t EIC129 @ 0xFFFFB102; EIC129->interrupt_channel=129;
    intc_edge_t EIC130 @ 0xFFFFB104; EIC130->interrupt_channel=130;
    intc_edge_t EIC131 @ 0xFFFFB106; EIC131->interrupt_channel=131;
    intc_edge_t EIC132 @ 0xFFFFB108; EIC132->interrupt_channel=132;
    intc_edge_t EIC137 @ 0xFFFFB112; EIC137->interrupt_channel=137;
    intc_edge_t EIC138 @ 0xFFFFB114; EIC138->interrupt_channel=138;
    intc_edge_t EIC139 @ 0xFFFFB116; EIC139->interrupt_channel=139;
    intc_edge_t EIC140 @ 0xFFFFB118; EIC140->interrupt_channel=140;
    intc_edge_t EIC141 @ 0xFFFFB11A; EIC141->interrupt_channel=141;
    intc_edge_t EIC142 @ 0xFFFFB11C; EIC142->interrupt_channel=142;
    intc_edge_t EIC143 @ 0xFFFFB11E; EIC143->interrupt_channel=143;
    intc_edge_t EIC144 @ 0xFFFFB120; EIC144->interrupt_channel=144;
    intc_edge_t EIC145 @ 0xFFFFB122; EIC145->interrupt_channel=145;
    intc_edge_t EIC146 @ 0xFFFFB124; EIC146->interrupt_channel=146;
    intc_edge_t EIC147 @ 0xFFFFB126; EIC147->interrupt_channel=147;
    intc_edge_t EIC148 @ 0xFFFFB128; EIC148->interrupt_channel=148;
    intc_edge_t EIC149 @ 0xFFFFB12A; EIC149->interrupt_channel=149;
    intc_edge_t EIC150 @ 0xFFFFB12C; EIC150->interrupt_channel=150;
    intc_edge_t EIC151 @ 0xFFFFB12E; EIC151->interrupt_channel=151;
    intc_edge_t EIC152 @ 0xFFFFB130; EIC152->interrupt_channel=152;
    intc_edge_t EIC153 @ 0xFFFFB132; EIC153->interrupt_channel=153;
    intc_edge_t EIC154 @ 0xFFFFB134; EIC154->interrupt_channel=154;
    intc_edge_t EIC155 @ 0xFFFFB136; EIC155->interrupt_channel=155;
    intc_edge_t EIC156 @ 0xFFFFB138; EIC156->interrupt_channel=156;
    intc_edge_t EIC158 @ 0xFFFFB13C; EIC158->interrupt_channel=158;
    intc_edge_t EIC159 @ 0xFFFFB13E; EIC159->interrupt_channel=159;
    intc_edge_t EIC160 @ 0xFFFFB140; EIC160->interrupt_channel=160;
    intc_edge_t EIC161 @ 0xFFFFB142; EIC161->interrupt_channel=161;
    intc_edge_t EIC162 @ 0xFFFFB144; EIC162->interrupt_channel=162;
    intc_edge_t EIC163 @ 0xFFFFB146; EIC163->interrupt_channel=163;
    intc_edge_t EIC164 @ 0xFFFFB148; EIC164->interrupt_channel=164;
    intc_edge_t EIC165 @ 0xFFFFB14A; EIC165->interrupt_channel=165;
    intc_edge_t EIC166 @ 0xFFFFB14C; EIC166->interrupt_channel=166;
    intc_edge_t EIC167 @ 0xFFFFB14E; EIC167->interrupt_channel=167;
    intc_edge_t EIC168 @ 0xFFFFB150; EIC168->interrupt_channel=168;
    intc_edge_t EIC169 @ 0xFFFFB152; EIC169->interrupt_channel=169;
    intc_edge_t EIC170 @ 0xFFFFB154; EIC170->interrupt_channel=170;
    intc_edge_t EIC171 @ 0xFFFFB156; EIC171->interrupt_channel=171;
    intc_edge_t EIC172 @ 0xFFFFB158; EIC172->interrupt_channel=172;
    intc_edge_t EIC173 @ 0xFFFFB15A; EIC173->interrupt_channel=173;
    intc_edge_t EIC174 @ 0xFFFFB15C; EIC174->interrupt_channel=174;
    intc_edge_t EIC175 @ 0xFFFFB15E; EIC175->interrupt_channel=175;
    intc_edge_t EIC176 @ 0xFFFFB160; EIC176->interrupt_channel=176;
    intc_edge_t EIC177 @ 0xFFFFB162; EIC177->interrupt_channel=177;
    intc_edge_t EIC178 @ 0xFFFFB164; EIC178->interrupt_channel=178;
    intc_edge_t EIC179 @ 0xFFFFB166; EIC179->interrupt_channel=179;
    intc_edge_t EIC180 @ 0xFFFFB168; EIC180->interrupt_channel=180;
    intc_edge_t EIC181 @ 0xFFFFB16A; EIC181->interrupt_channel=181;
    intc_edge_t EIC182 @ 0xFFFFB16C; EIC182->interrupt_channel=182;
    intc_level_t EIC183 @ 0xFFFFB16E; EIC183->interrupt_channel=183;
    intc_level_t EIC184 @ 0xFFFFB170; EIC184->interrupt_channel=184;
    intc_level_t EIC185 @ 0xFFFFB172; EIC185->interrupt_channel=185;
    intc_level_t EIC186 @ 0xFFFFB174; EIC186->interrupt_channel=186;
    intc_level_t EIC189 @ 0xFFFFB17A; EIC189->interrupt_channel=189;
    intc_level_t EIC190 @ 0xFFFFB17C; EIC190->interrupt_channel=190;
    intc_level_t EIC191 @ 0xFFFFB17E; EIC191->interrupt_channel=191;
    intc_level_t EIC192 @ 0xFFFFB180; EIC192->interrupt_channel=192;
    intc_level_t EIC193 @ 0xFFFFB182; EIC193->interrupt_channel=193;
    intc_level_t EIC194 @ 0xFFFFB184; EIC194->interrupt_channel=194;
    intc_level_t EIC195 @ 0xFFFFB186; EIC195->interrupt_channel=195;
    intc_level_t EIC196 @ 0xFFFFB188; EIC196->interrupt_channel=196;
    intc_level_t EIC197 @ 0xFFFFB18A; EIC197->interrupt_channel=197;
    intc_level_t EIC198 @ 0xFFFFB18C; EIC198->interrupt_channel=198;
    intc_level_t EIC199 @ 0xFFFFB18E; EIC199->interrupt_channel=199;
    intc_level_t EIC200 @ 0xFFFFB190; EIC200->interrupt_channel=200;
    intc_level_t EIC201 @ 0xFFFFB192; EIC201->interrupt_channel=201;
    intc_level_t EIC202 @ 0xFFFFB194; EIC202->interrupt_channel=202;
    intc_level_t EIC203 @ 0xFFFFB196; EIC203->interrupt_channel=203;
    intc_level_t EIC204 @ 0xFFFFB198; EIC204->interrupt_channel=204;
    intc_level_t EIC218 @ 0xFFFFB1B4; EIC218->interrupt_channel=218;
    intc_edge_t EIC219 @ 0xFFFFB1B6; EIC219->interrupt_channel=219;
    intc_edge_t EIC220 @ 0xFFFFB1B8; EIC220->interrupt_channel=220;
    intc_level_t EIC221 @ 0xFFFFB1BA; EIC221->interrupt_channel=221;
    intc_level_t EIC226 @ 0xFFFFB1C4; EIC226->interrupt_channel=226;
    intc_level_t EIC227 @ 0xFFFFB1C6; EIC227->interrupt_channel=227;
    intc_level_t EIC228 @ 0xFFFFB1C8; EIC228->interrupt_channel=228;
    intc_level_t EIC229 @ 0xFFFFB1CA; EIC229->interrupt_channel=229;
    intc_level_t EIC230 @ 0xFFFFB1CC; EIC230->interrupt_channel=230;
    intc_level_t EIC231 @ 0xFFFFB1CE; EIC231->interrupt_channel=231;
    intc_level_t EIC232 @ 0xFFFFB1D0; EIC232->interrupt_channel=232;
    intc_edge_t EIC233 @ 0xFFFFB1D2; EIC233->interrupt_channel=233;
    intc_level_t EIC234 @ 0xFFFFB1D4; EIC234->interrupt_channel=234;
    intc_edge_t EIC235 @ 0xFFFFB1D6; EIC235->interrupt_channel=235;
    intc_level_t EIC236 @ 0xFFFFB1D8; EIC236->interrupt_channel=236;
    intc_edge_t EIC237 @ 0xFFFFB1DA; EIC237->interrupt_channel=237;
    intc_level_t EIC238 @ 0xFFFFB1DC; EIC238->interrupt_channel=238;
    intc_edge_t EIC239 @ 0xFFFFB1DE; EIC239->interrupt_channel=239;
    intc_level_t EIC240 @ 0xFFFFB1E0; EIC240->interrupt_channel=240;
    intc_edge_t EIC241 @ 0xFFFFB1E2; EIC241->interrupt_channel=241;
    intc_level_t EIC242 @ 0xFFFFB1E4; EIC242->interrupt_channel=242;
    intc_edge_t EIC243 @ 0xFFFFB1E6; EIC243->interrupt_channel=243;
    intc_level_t EIC244 @ 0xFFFFB1E8; EIC244->interrupt_channel=244;
    intc_level_t EIC245 @ 0xFFFFB1EA; EIC245->interrupt_channel=245;
    intc_level_t EIC246 @ 0xFFFFB1EC; EIC246->interrupt_channel=246;
    intc_level_t EIC247 @ 0xFFFFB1EE; EIC247->interrupt_channel=247;
    intc_level_t EIC248 @ 0xFFFFB1F0; EIC248->interrupt_channel=248;
    intc_level_t EIC249 @ 0xFFFFB1F2; EIC249->interrupt_channel=249;
    intc_level_t EIC250 @ 0xFFFFB1F4; EIC250->interrupt_channel=250;
    intc_level_t EIC251 @ 0xFFFFB1F6; EIC251->interrupt_channel=251;
    intc_level_t EIC252 @ 0xFFFFB1F8; EIC252->interrupt_channel=252;
    intc_level_t EIC253 @ 0xFFFFB1FA; EIC253->interrupt_channel=253;
    intc_level_t EIC254 @ 0xFFFFB1FC; EIC254->interrupt_channel=254;
    intc_edge_t EIC256 @ 0xFFFFB200; EIC256->interrupt_channel=256;
    intc_edge_t EIC257 @ 0xFFFFB202; EIC257->interrupt_channel=257;
    intc_edge_t EIC258 @ 0xFFFFB204; EIC258->interrupt_channel=258;
    intc_edge_t EIC259 @ 0xFFFFB206; EIC259->interrupt_channel=259;
    intc_edge_t EIC260 @ 0xFFFFB208; EIC260->interrupt_channel=260;
    intc_edge_t EIC261 @ 0xFFFFB20A; EIC261->interrupt_channel=261;
    intc_edge_t EIC262 @ 0xFFFFB20C; EIC262->interrupt_channel=262;
    intc_edge_t EIC263 @ 0xFFFFB20E; EIC263->interrupt_channel=263;
    intc_edge_t EIC264 @ 0xFFFFB210; EIC264->interrupt_channel=264;
    intc_edge_t EIC265 @ 0xFFFFB212; EIC265->interrupt_channel=265;
    intc_edge_t EIC266 @ 0xFFFFB214; EIC266->interrupt_channel=266;
    intc_edge_t EIC267 @ 0xFFFFB216; EIC267->interrupt_channel=267;
    intc_edge_t EIC268 @ 0xFFFFB218; EIC268->interrupt_channel=268;
    intc_edge_t EIC269 @ 0xFFFFB21A; EIC269->interrupt_channel=269;
    intc_edge_t EIC270 @ 0xFFFFB21C; EIC270->interrupt_channel=270;
    intc_edge_t EIC271 @ 0xFFFFB21E; EIC271->interrupt_channel=271;
    intc_edge_t EIC272 @ 0xFFFFB220; EIC272->interrupt_channel=272;
    intc_edge_t EIC273 @ 0xFFFFB222; EIC273->interrupt_channel=273;
    intc_edge_t EIC274 @ 0xFFFFB224; EIC274->interrupt_channel=274;
    intc_edge_t EIC275 @ 0xFFFFB226; EIC275->interrupt_channel=275;
    intc_edge_t EIC276 @ 0xFFFFB228; EIC276->interrupt_channel=276;
    intc_edge_t EIC277 @ 0xFFFFB22A; EIC277->interrupt_channel=277;
    intc_edge_t EIC278 @ 0xFFFFB22C; EIC278->interrupt_channel=278;
    intc_edge_t EIC279 @ 0xFFFFB22E; EIC279->interrupt_channel=279;
    intc_edge_t EIC280 @ 0xFFFFB230; EIC280->interrupt_channel=280;
    intc_edge_t EIC281 @ 0xFFFFB232; EIC281->interrupt_channel=281;
    intc_edge_t EIC282 @ 0xFFFFB234; EIC282->interrupt_channel=282;
    intc_edge_t EIC283 @ 0xFFFFB236; EIC283->interrupt_channel=283;
    intc_edge_t EIC284 @ 0xFFFFB238; EIC284->interrupt_channel=284;
    intc_edge_t EIC285 @ 0xFFFFB23A; EIC285->interrupt_channel=285;
    intc_edge_t EIC286 @ 0xFFFFB23C; EIC286->interrupt_channel=286;
    intc_edge_t EIC287 @ 0xFFFFB23E; EIC287->interrupt_channel=287;
    intc_edge_t EIC288 @ 0xFFFFB240; EIC288->interrupt_channel=288;
    intc_edge_t EIC289 @ 0xFFFFB242; EIC289->interrupt_channel=289;
    intc_edge_t EIC290 @ 0xFFFFB244; EIC290->interrupt_channel=290;
    intc_edge_t EIC291 @ 0xFFFFB246; EIC291->interrupt_channel=291;
    intc_edge_t EIC294 @ 0xFFFFB24C; EIC294->interrupt_channel=294;
    intc_edge_t EIC295 @ 0xFFFFB24E; EIC295->interrupt_channel=295;
    intc_edge_t EIC296 @ 0xFFFFB250; EIC296->interrupt_channel=296;
    intc_edge_t EIC297 @ 0xFFFFB252; EIC297->interrupt_channel=297;
    intc_edge_t EIC298 @ 0xFFFFB254; EIC298->interrupt_channel=298;
    intc_level_t EIC383 @ 0xFFFFB2FE; EIC383->interrupt_channel=383;

    reg {
        regwidth=16; accesswidth=16; desc="ECM maskable-error interrupt control (EIINT 8); EIRF bit 12, EIMK bit 7, EITB bit 6, EIP[3:0], EICT bit 15; synchronous edge detection";
        evidence="manual"; source_ref="R01UH0585EJ0120 section 6.2.2 Table 6.4, Table 6.11; SFR list FFFEEA10"; behavior="intc_eic";
        interrupt_channel=8;
        access_widths="1,2";
        field { sw=rw; reset=0x8F; } value[15:0];
    } EIC8 @ 0xFFFEEA10;

    reg {
        regwidth=16; accesswidth=16; desc="TAUJ0 CH0 interrupt control (EIINT 133, INTTAUJ0I0); synchronous edge detection: EIRF bit 12 auto-cleared on CPU acceptance; source code 0x1085, INTBP offset +214H";
        evidence="manual"; source_ref="R01UH0585EJ0120 section 6.2.2 Table 6.4, Table 6.11"; behavior="intc_eic";
        interrupt_channel=133;
        access_widths="1,2";
        field { sw=rw; reset=0x8F; } value[15:0];
    } EIC133 @ 0xFFFFB10A;

    reg {
        regwidth=16; accesswidth=16; desc="TAUJ0 CH1 interrupt control (EIINT 134, INTTAUJ0I1); synchronous edge detection; source code 0x1086, INTBP offset +218H";
        evidence="manual"; source_ref="R01UH0585EJ0120 section 6.2.2 Table 6.4, Table 6.11"; behavior="intc_eic";
        interrupt_channel=134;
        access_widths="1,2";
        field { sw=rw; reset=0x8F; } value[15:0];
    } EIC134 @ 0xFFFFB10C;

    reg {
        regwidth=16; accesswidth=16; desc="TAUJ0 CH2 interrupt control (EIINT 135, INTTAUJ0I2); synchronous edge detection; source code 0x1087, INTBP offset +21CH";
        evidence="manual"; source_ref="R01UH0585EJ0120 section 6.2.2 Table 6.4, Table 6.11"; behavior="intc_eic";
        interrupt_channel=135;
        access_widths="1,2";
        field { sw=rw; reset=0x8F; } value[15:0];
    } EIC135 @ 0xFFFFB10E;

    reg {
        regwidth=16; accesswidth=16; desc="TAUJ0 CH3 interrupt control (EIINT 136, INTTAUJ0I3; foreground tick; EIRF bit 12 polled); synchronous edge detection; source code 0x1088, INTBP offset +220H";
        evidence="manual"; source_ref="R01UH0585EJ0120 section 6.2.2 Table 6.4, Table 6.11"; behavior="intc_eic";
        interrupt_channel=136;
        access_widths="1,2";
        field { sw=rw; reset=0x8F; } value[15:0];
    } EIC136 @ 0xFFFFB110;

    reg {
        regwidth=16; accesswidth=16; desc="RSCFD CAN1 transmit/receive-FIFO receive-completion interrupt control (EIINT 187, INTRCAN1REC; CFIFO receive path); high-level detection: EIRF bit 12 read-only, follows CFRXIF gated by CFRXIE, not cleared by acceptance; source code 0x10BB, INTBP offset +2ECH";
        evidence="manual"; source_ref="R01UH0585EJ0120 section 6.2.2 Table 6.4, Tables 6.11 and 17.8"; behavior="intc_eic";
        interrupt_channel=187;
        access_widths="1,2";
        field { sw=rw; reset=0x808F; } value[15:0];
    } EIC187 @ 0xFFFFB176;

    reg {
        regwidth=16; accesswidth=16; desc="RSCFD CAN1 transmit interrupt control (EIINT 188, INTRCAN1TRX); high-level detection: EIRF bit 12 read-only; source code 0x10BC, INTBP offset +2F0H";
        evidence="manual"; source_ref="R01UH0585EJ0120 section 6.2.2 Table 6.4, Tables 6.11 and 17.8"; behavior="intc_eic";
        interrupt_channel=188;
        access_widths="1,2";
        field { sw=rw; reset=0x808F; } value[15:0];
    } EIC188 @ 0xFFFFB178;

    reg {
        regwidth=16; accesswidth=16; desc="Recovered exact-firmware EIINT292 priority storage; reserved in public Table6.11; no documented peripheral request source or reset value";
        evidence="manual+firmware"; source_ref="R01UH0585EJ0120 Table6.11 reserved292; camry-8965F3307000 initialize_interrupt_control_words_and_verify_priorities_62e6a software write/readback"; behavior="intc_eic";
        interrupt_channel=292;
        access_widths="1,2";
        field { sw=rw; } value[15:0];
    } EIC292 @ 0xFFFFB248;

    reg {
        regwidth=16; accesswidth=16; desc="Recovered exact-firmware EIINT293 priority storage; reserved in public Table6.11; no documented peripheral request source or reset value";
        evidence="manual+firmware"; source_ref="R01UH0585EJ0120 Table6.11 reserved293; camry-8965F3307000 initialize_interrupt_control_words_and_verify_priorities_62e6a software write/readback"; behavior="intc_eic";
        interrupt_channel=293;
        access_widths="1,2";
        field { sw=rw; } value[15:0];
    } EIC293 @ 0xFFFFB24A;

    reg {
        regwidth=16; accesswidth=16; desc="Flash sequencer-end interrupt control (EIINT 379, INTFLENDNM); synchronous edge detection; source code 0x117B, INTBP offset +5ECH";
        evidence="manual"; source_ref="R01UH0585EJ0120 section 6.2.2 Table 6.4, Table 6.11; SFR list FFFFB2F6"; behavior="intc_eic";
        interrupt_channel=379;
        access_widths="1,2";
        field { sw=rw; reset=0x8F; } value[15:0];
    } EIC379 @ 0xFFFFB2F6;

    reg {
        regwidth=32; accesswidth=32; desc="Flash program/erase/blank-check software enable, bit0; reset excludes application reset 1";
        evidence="manual"; source_ref="R01UH0585EJ0120 page2878 Table35.16"; behavior="faci";
        trigger="faci-enable";
        reset_classes="power-on,system-1-cvm,system-1-pin,system-2";
        field { sw=rw; reset=0; } value[31:0];
    } FHVE3 @ 0xFFF82410;

    reg {
        regwidth=32; accesswidth=32; desc="Flash program/erase/blank-check software enable, bit0; both FHVE controls must be one";
        evidence="manual"; source_ref="R01UH0585EJ0120 page2877 Tables35.14-35.15"; behavior="faci";
        trigger="faci-enable";
        reset_classes="power-on,system-1-cvm,system-1-pin,system-2";
        field { sw=rw; reset=0; } value[31:0];
    } FHVE15 @ 0xFFF8A430;
};
